******************** HSPICE BASIC GATES MODELING ********************
*
*   Mohammad Khoshroo - 810102441
*   Spring 2026
*   AVLSI Course - by Dr. Vahdat
*   Thechnolegy - crn90g_2d5_lk_v1d2p1.l (90nm)
*   Standard MOSFET Model Name : nch , pch
*   Brent-Kung Adder 8-bit SIMULATION POWER STATIC
*   CORNER FF
*
**************************** PARAMETERS *****************************

.OPTION NOMOD
.LIB "../../../../../../include/crn90g_2d5_lk_v1d2p1.lib" FF
.INC "../../../../../../include/BKA.inc"
.VEC "input.vec"

.PARAM Vdd_val = 1                  $ supply-1 voltage
.PARAM Vss_val = 0                  $ supply-0 voltage
.PARAM beta = 2                     $ un/up
.PARAM L = 180n                     $ Channel length
.PARAM Wn_min = 1u                  $ Minimum Transistor width for n-types
.PARAM Wp_min = 'beta * Wn_min'     $ Minimum Transistor width for p-types
.PARAM tr = 50p

****************************** CIRCUIT ******************************

XBKA A8 A7 A6 A5 A4 A3 A2 A1
+    B8 B7 B6 B5 B4 B3 B2 B1 Cin
+    S8 S7 S6 S5 S4 S3 S2 S1 Cout Vdd Vss BKA8 $ Brent-Kung Adder 8-bit GATE Under TEST/SIMULATION

************************* SIMULATION SETTING ************************

* Supplys Voltage Node
Vdd  Vdd 0 DC 'Vdd_val'
Vss  Vss 0 DC 'Vss_val'

.TRAN 1p 130000p

* ===================================================================
* Power (P)

.MEASURE TRAN P_static_0 AVG POWER FROM=1000ps TO=1300ps
.MEASURE TRAN P_static_1 AVG POWER FROM=2300ps TO=2600ps
.MEASURE TRAN P_static_2 AVG POWER FROM=3600ps TO=3900ps
.MEASURE TRAN P_static_3 AVG POWER FROM=4900ps TO=5200ps
.MEASURE TRAN P_static_4 AVG POWER FROM=6200ps TO=6500ps
.MEASURE TRAN P_static_5 AVG POWER FROM=7500ps TO=7800ps
.MEASURE TRAN P_static_6 AVG POWER FROM=8800ps TO=9100ps
.MEASURE TRAN P_static_7 AVG POWER FROM=10100ps TO=10400ps
.MEASURE TRAN P_static_8 AVG POWER FROM=11400ps TO=11700ps
.MEASURE TRAN P_static_9 AVG POWER FROM=12700ps TO=13000ps
.MEASURE TRAN P_static_10 AVG POWER FROM=14000ps TO=14300ps
.MEASURE TRAN P_static_11 AVG POWER FROM=15300ps TO=15600ps
.MEASURE TRAN P_static_12 AVG POWER FROM=16600ps TO=16900ps
.MEASURE TRAN P_static_13 AVG POWER FROM=17900ps TO=18200ps
.MEASURE TRAN P_static_14 AVG POWER FROM=19200ps TO=19500ps
.MEASURE TRAN P_static_15 AVG POWER FROM=20500ps TO=20800ps
.MEASURE TRAN P_static_16 AVG POWER FROM=21800ps TO=22100ps
.MEASURE TRAN P_static_17 AVG POWER FROM=23100ps TO=23400ps
.MEASURE TRAN P_static_18 AVG POWER FROM=24400ps TO=24700ps
.MEASURE TRAN P_static_19 AVG POWER FROM=25700ps TO=26000ps
.MEASURE TRAN P_static_20 AVG POWER FROM=27000ps TO=27300ps
.MEASURE TRAN P_static_21 AVG POWER FROM=28300ps TO=28600ps
.MEASURE TRAN P_static_22 AVG POWER FROM=29600ps TO=29900ps
.MEASURE TRAN P_static_23 AVG POWER FROM=30900ps TO=31200ps
.MEASURE TRAN P_static_24 AVG POWER FROM=32200ps TO=32500ps
.MEASURE TRAN P_static_25 AVG POWER FROM=33500ps TO=33800ps
.MEASURE TRAN P_static_26 AVG POWER FROM=34800ps TO=35100ps
.MEASURE TRAN P_static_27 AVG POWER FROM=36100ps TO=36400ps
.MEASURE TRAN P_static_28 AVG POWER FROM=37400ps TO=37700ps
.MEASURE TRAN P_static_29 AVG POWER FROM=38700ps TO=39000ps
.MEASURE TRAN P_static_30 AVG POWER FROM=40000ps TO=40300ps
.MEASURE TRAN P_static_31 AVG POWER FROM=41300ps TO=41600ps
.MEASURE TRAN P_static_32 AVG POWER FROM=42600ps TO=42900ps
.MEASURE TRAN P_static_33 AVG POWER FROM=43900ps TO=44200ps
.MEASURE TRAN P_static_34 AVG POWER FROM=45200ps TO=45500ps
.MEASURE TRAN P_static_35 AVG POWER FROM=46500ps TO=46800ps
.MEASURE TRAN P_static_36 AVG POWER FROM=47800ps TO=48100ps
.MEASURE TRAN P_static_37 AVG POWER FROM=49100ps TO=49400ps
.MEASURE TRAN P_static_38 AVG POWER FROM=50400ps TO=50700ps
.MEASURE TRAN P_static_39 AVG POWER FROM=51700ps TO=52000ps
.MEASURE TRAN P_static_40 AVG POWER FROM=53000ps TO=53300ps
.MEASURE TRAN P_static_41 AVG POWER FROM=54300ps TO=54600ps
.MEASURE TRAN P_static_42 AVG POWER FROM=55600ps TO=55900ps
.MEASURE TRAN P_static_43 AVG POWER FROM=56900ps TO=57200ps
.MEASURE TRAN P_static_44 AVG POWER FROM=58200ps TO=58500ps
.MEASURE TRAN P_static_45 AVG POWER FROM=59500ps TO=59800ps
.MEASURE TRAN P_static_46 AVG POWER FROM=60800ps TO=61100ps
.MEASURE TRAN P_static_47 AVG POWER FROM=62100ps TO=62400ps
.MEASURE TRAN P_static_48 AVG POWER FROM=63400ps TO=63700ps
.MEASURE TRAN P_static_49 AVG POWER FROM=64700ps TO=65000ps
.MEASURE TRAN P_static_50 AVG POWER FROM=66000ps TO=66300ps
.MEASURE TRAN P_static_51 AVG POWER FROM=67300ps TO=67600ps
.MEASURE TRAN P_static_52 AVG POWER FROM=68600ps TO=68900ps
.MEASURE TRAN P_static_53 AVG POWER FROM=69900ps TO=70200ps
.MEASURE TRAN P_static_54 AVG POWER FROM=71200ps TO=71500ps
.MEASURE TRAN P_static_55 AVG POWER FROM=72500ps TO=72800ps
.MEASURE TRAN P_static_56 AVG POWER FROM=73800ps TO=74100ps
.MEASURE TRAN P_static_57 AVG POWER FROM=75100ps TO=75400ps
.MEASURE TRAN P_static_58 AVG POWER FROM=76400ps TO=76700ps
.MEASURE TRAN P_static_59 AVG POWER FROM=77700ps TO=78000ps
.MEASURE TRAN P_static_60 AVG POWER FROM=79000ps TO=79300ps
.MEASURE TRAN P_static_61 AVG POWER FROM=80300ps TO=80600ps
.MEASURE TRAN P_static_62 AVG POWER FROM=81600ps TO=81900ps
.MEASURE TRAN P_static_63 AVG POWER FROM=82900ps TO=83200ps
.MEASURE TRAN P_static_64 AVG POWER FROM=84200ps TO=84500ps
.MEASURE TRAN P_static_65 AVG POWER FROM=85500ps TO=85800ps
.MEASURE TRAN P_static_66 AVG POWER FROM=86800ps TO=87100ps
.MEASURE TRAN P_static_67 AVG POWER FROM=88100ps TO=88400ps
.MEASURE TRAN P_static_68 AVG POWER FROM=89400ps TO=89700ps
.MEASURE TRAN P_static_69 AVG POWER FROM=90700ps TO=91000ps
.MEASURE TRAN P_static_70 AVG POWER FROM=92000ps TO=92300ps
.MEASURE TRAN P_static_71 AVG POWER FROM=93300ps TO=93600ps
.MEASURE TRAN P_static_72 AVG POWER FROM=94600ps TO=94900ps
.MEASURE TRAN P_static_73 AVG POWER FROM=95900ps TO=96200ps
.MEASURE TRAN P_static_74 AVG POWER FROM=97200ps TO=97500ps
.MEASURE TRAN P_static_75 AVG POWER FROM=98500ps TO=98800ps
.MEASURE TRAN P_static_76 AVG POWER FROM=99800ps TO=100100ps
.MEASURE TRAN P_static_77 AVG POWER FROM=101100ps TO=101400ps
.MEASURE TRAN P_static_78 AVG POWER FROM=102400ps TO=102700ps
.MEASURE TRAN P_static_79 AVG POWER FROM=103700ps TO=104000ps
.MEASURE TRAN P_static_80 AVG POWER FROM=105000ps TO=105300ps
.MEASURE TRAN P_static_81 AVG POWER FROM=106300ps TO=106600ps
.MEASURE TRAN P_static_82 AVG POWER FROM=107600ps TO=107900ps
.MEASURE TRAN P_static_83 AVG POWER FROM=108900ps TO=109200ps
.MEASURE TRAN P_static_84 AVG POWER FROM=110200ps TO=110500ps
.MEASURE TRAN P_static_85 AVG POWER FROM=111500ps TO=111800ps
.MEASURE TRAN P_static_86 AVG POWER FROM=112800ps TO=113100ps
.MEASURE TRAN P_static_87 AVG POWER FROM=114100ps TO=114400ps
.MEASURE TRAN P_static_88 AVG POWER FROM=115400ps TO=115700ps
.MEASURE TRAN P_static_89 AVG POWER FROM=116700ps TO=117000ps
.MEASURE TRAN P_static_90 AVG POWER FROM=118000ps TO=118300ps
.MEASURE TRAN P_static_91 AVG POWER FROM=119300ps TO=119600ps
.MEASURE TRAN P_static_92 AVG POWER FROM=120600ps TO=120900ps
.MEASURE TRAN P_static_93 AVG POWER FROM=121900ps TO=122200ps
.MEASURE TRAN P_static_94 AVG POWER FROM=123200ps TO=123500ps
.MEASURE TRAN P_static_95 AVG POWER FROM=124500ps TO=124800ps
.MEASURE TRAN P_static_96 AVG POWER FROM=125800ps TO=126100ps
.MEASURE TRAN P_static_97 AVG POWER FROM=127100ps TO=127400ps
.MEASURE TRAN P_static_98 AVG POWER FROM=128400ps TO=128700ps
.MEASURE TRAN P_static_99 AVG POWER FROM=129700ps TO=130000ps

*************************** OUTPUT SETTING **************************

.OPTION POST=2 PROBE
.PROBE V(Cout) V(Cin)
+      V(A8) V(A1) V(A2) V(A3) V(A4) V(A5) V(A6) V(A7)
+      V(B8) V(B1) V(B2) V(B3) V(B4) V(B5) V(B6) V(B7)
+      V(S8) V(S1) V(S2) V(S3) V(S4) V(S5) V(S6) V(S7)

.END
