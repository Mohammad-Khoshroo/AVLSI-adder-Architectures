.PARAM Vdd_val = 1                  $ Positive power supply voltage
.PARAM Vss_val = 0                  $ Ground voltage
.PARAM beta = 2                     $ Mobility ratio (mu_n/mu_p)
.PARAM L = 180n                     $ Channel length
.PARAM Wn_min = 1u                  $ Minimum width for NMOS transistors
.PARAM Wp_min = 'beta * Wn_min'     $ Minimum width for PMOS transistors
