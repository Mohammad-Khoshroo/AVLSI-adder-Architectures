* --- HSPICE Static Power Measurements for each vector ---
* Total Vectors: 1000

.MEASURE TRAN P_static_0 AVG POWER FROM=1000ps TO=1300ps
.MEASURE TRAN P_static_1 AVG POWER FROM=2300ps TO=2600ps
.MEASURE TRAN P_static_2 AVG POWER FROM=3600ps TO=3900ps
.MEASURE TRAN P_static_3 AVG POWER FROM=4900ps TO=5200ps
.MEASURE TRAN P_static_4 AVG POWER FROM=6200ps TO=6500ps
.MEASURE TRAN P_static_5 AVG POWER FROM=7500ps TO=7800ps
.MEASURE TRAN P_static_6 AVG POWER FROM=8800ps TO=9100ps
.MEASURE TRAN P_static_7 AVG POWER FROM=10100ps TO=10400ps
.MEASURE TRAN P_static_8 AVG POWER FROM=11400ps TO=11700ps
.MEASURE TRAN P_static_9 AVG POWER FROM=12700ps TO=13000ps
.MEASURE TRAN P_static_10 AVG POWER FROM=14000ps TO=14300ps
.MEASURE TRAN P_static_11 AVG POWER FROM=15300ps TO=15600ps
.MEASURE TRAN P_static_12 AVG POWER FROM=16600ps TO=16900ps
.MEASURE TRAN P_static_13 AVG POWER FROM=17900ps TO=18200ps
.MEASURE TRAN P_static_14 AVG POWER FROM=19200ps TO=19500ps
.MEASURE TRAN P_static_15 AVG POWER FROM=20500ps TO=20800ps
.MEASURE TRAN P_static_16 AVG POWER FROM=21800ps TO=22100ps
.MEASURE TRAN P_static_17 AVG POWER FROM=23100ps TO=23400ps
.MEASURE TRAN P_static_18 AVG POWER FROM=24400ps TO=24700ps
.MEASURE TRAN P_static_19 AVG POWER FROM=25700ps TO=26000ps
.MEASURE TRAN P_static_20 AVG POWER FROM=27000ps TO=27300ps
.MEASURE TRAN P_static_21 AVG POWER FROM=28300ps TO=28600ps
.MEASURE TRAN P_static_22 AVG POWER FROM=29600ps TO=29900ps
.MEASURE TRAN P_static_23 AVG POWER FROM=30900ps TO=31200ps
.MEASURE TRAN P_static_24 AVG POWER FROM=32200ps TO=32500ps
.MEASURE TRAN P_static_25 AVG POWER FROM=33500ps TO=33800ps
.MEASURE TRAN P_static_26 AVG POWER FROM=34800ps TO=35100ps
.MEASURE TRAN P_static_27 AVG POWER FROM=36100ps TO=36400ps
.MEASURE TRAN P_static_28 AVG POWER FROM=37400ps TO=37700ps
.MEASURE TRAN P_static_29 AVG POWER FROM=38700ps TO=39000ps
.MEASURE TRAN P_static_30 AVG POWER FROM=40000ps TO=40300ps
.MEASURE TRAN P_static_31 AVG POWER FROM=41300ps TO=41600ps
.MEASURE TRAN P_static_32 AVG POWER FROM=42600ps TO=42900ps
.MEASURE TRAN P_static_33 AVG POWER FROM=43900ps TO=44200ps
.MEASURE TRAN P_static_34 AVG POWER FROM=45200ps TO=45500ps
.MEASURE TRAN P_static_35 AVG POWER FROM=46500ps TO=46800ps
.MEASURE TRAN P_static_36 AVG POWER FROM=47800ps TO=48100ps
.MEASURE TRAN P_static_37 AVG POWER FROM=49100ps TO=49400ps
.MEASURE TRAN P_static_38 AVG POWER FROM=50400ps TO=50700ps
.MEASURE TRAN P_static_39 AVG POWER FROM=51700ps TO=52000ps
.MEASURE TRAN P_static_40 AVG POWER FROM=53000ps TO=53300ps
.MEASURE TRAN P_static_41 AVG POWER FROM=54300ps TO=54600ps
.MEASURE TRAN P_static_42 AVG POWER FROM=55600ps TO=55900ps
.MEASURE TRAN P_static_43 AVG POWER FROM=56900ps TO=57200ps
.MEASURE TRAN P_static_44 AVG POWER FROM=58200ps TO=58500ps
.MEASURE TRAN P_static_45 AVG POWER FROM=59500ps TO=59800ps
.MEASURE TRAN P_static_46 AVG POWER FROM=60800ps TO=61100ps
.MEASURE TRAN P_static_47 AVG POWER FROM=62100ps TO=62400ps
.MEASURE TRAN P_static_48 AVG POWER FROM=63400ps TO=63700ps
.MEASURE TRAN P_static_49 AVG POWER FROM=64700ps TO=65000ps
.MEASURE TRAN P_static_50 AVG POWER FROM=66000ps TO=66300ps
.MEASURE TRAN P_static_51 AVG POWER FROM=67300ps TO=67600ps
.MEASURE TRAN P_static_52 AVG POWER FROM=68600ps TO=68900ps
.MEASURE TRAN P_static_53 AVG POWER FROM=69900ps TO=70200ps
.MEASURE TRAN P_static_54 AVG POWER FROM=71200ps TO=71500ps
.MEASURE TRAN P_static_55 AVG POWER FROM=72500ps TO=72800ps
.MEASURE TRAN P_static_56 AVG POWER FROM=73800ps TO=74100ps
.MEASURE TRAN P_static_57 AVG POWER FROM=75100ps TO=75400ps
.MEASURE TRAN P_static_58 AVG POWER FROM=76400ps TO=76700ps
.MEASURE TRAN P_static_59 AVG POWER FROM=77700ps TO=78000ps
.MEASURE TRAN P_static_60 AVG POWER FROM=79000ps TO=79300ps
.MEASURE TRAN P_static_61 AVG POWER FROM=80300ps TO=80600ps
.MEASURE TRAN P_static_62 AVG POWER FROM=81600ps TO=81900ps
.MEASURE TRAN P_static_63 AVG POWER FROM=82900ps TO=83200ps
.MEASURE TRAN P_static_64 AVG POWER FROM=84200ps TO=84500ps
.MEASURE TRAN P_static_65 AVG POWER FROM=85500ps TO=85800ps
.MEASURE TRAN P_static_66 AVG POWER FROM=86800ps TO=87100ps
.MEASURE TRAN P_static_67 AVG POWER FROM=88100ps TO=88400ps
.MEASURE TRAN P_static_68 AVG POWER FROM=89400ps TO=89700ps
.MEASURE TRAN P_static_69 AVG POWER FROM=90700ps TO=91000ps
.MEASURE TRAN P_static_70 AVG POWER FROM=92000ps TO=92300ps
.MEASURE TRAN P_static_71 AVG POWER FROM=93300ps TO=93600ps
.MEASURE TRAN P_static_72 AVG POWER FROM=94600ps TO=94900ps
.MEASURE TRAN P_static_73 AVG POWER FROM=95900ps TO=96200ps
.MEASURE TRAN P_static_74 AVG POWER FROM=97200ps TO=97500ps
.MEASURE TRAN P_static_75 AVG POWER FROM=98500ps TO=98800ps
.MEASURE TRAN P_static_76 AVG POWER FROM=99800ps TO=100100ps
.MEASURE TRAN P_static_77 AVG POWER FROM=101100ps TO=101400ps
.MEASURE TRAN P_static_78 AVG POWER FROM=102400ps TO=102700ps
.MEASURE TRAN P_static_79 AVG POWER FROM=103700ps TO=104000ps
.MEASURE TRAN P_static_80 AVG POWER FROM=105000ps TO=105300ps
.MEASURE TRAN P_static_81 AVG POWER FROM=106300ps TO=106600ps
.MEASURE TRAN P_static_82 AVG POWER FROM=107600ps TO=107900ps
.MEASURE TRAN P_static_83 AVG POWER FROM=108900ps TO=109200ps
.MEASURE TRAN P_static_84 AVG POWER FROM=110200ps TO=110500ps
.MEASURE TRAN P_static_85 AVG POWER FROM=111500ps TO=111800ps
.MEASURE TRAN P_static_86 AVG POWER FROM=112800ps TO=113100ps
.MEASURE TRAN P_static_87 AVG POWER FROM=114100ps TO=114400ps
.MEASURE TRAN P_static_88 AVG POWER FROM=115400ps TO=115700ps
.MEASURE TRAN P_static_89 AVG POWER FROM=116700ps TO=117000ps
.MEASURE TRAN P_static_90 AVG POWER FROM=118000ps TO=118300ps
.MEASURE TRAN P_static_91 AVG POWER FROM=119300ps TO=119600ps
.MEASURE TRAN P_static_92 AVG POWER FROM=120600ps TO=120900ps
.MEASURE TRAN P_static_93 AVG POWER FROM=121900ps TO=122200ps
.MEASURE TRAN P_static_94 AVG POWER FROM=123200ps TO=123500ps
.MEASURE TRAN P_static_95 AVG POWER FROM=124500ps TO=124800ps
.MEASURE TRAN P_static_96 AVG POWER FROM=125800ps TO=126100ps
.MEASURE TRAN P_static_97 AVG POWER FROM=127100ps TO=127400ps
.MEASURE TRAN P_static_98 AVG POWER FROM=128400ps TO=128700ps
.MEASURE TRAN P_static_99 AVG POWER FROM=129700ps TO=130000ps
.MEASURE TRAN P_static_100 AVG POWER FROM=131000ps TO=131300ps
.MEASURE TRAN P_static_101 AVG POWER FROM=132300ps TO=132600ps
.MEASURE TRAN P_static_102 AVG POWER FROM=133600ps TO=133900ps
.MEASURE TRAN P_static_103 AVG POWER FROM=134900ps TO=135200ps
.MEASURE TRAN P_static_104 AVG POWER FROM=136200ps TO=136500ps
.MEASURE TRAN P_static_105 AVG POWER FROM=137500ps TO=137800ps
.MEASURE TRAN P_static_106 AVG POWER FROM=138800ps TO=139100ps
.MEASURE TRAN P_static_107 AVG POWER FROM=140100ps TO=140400ps
.MEASURE TRAN P_static_108 AVG POWER FROM=141400ps TO=141700ps
.MEASURE TRAN P_static_109 AVG POWER FROM=142700ps TO=143000ps
.MEASURE TRAN P_static_110 AVG POWER FROM=144000ps TO=144300ps
.MEASURE TRAN P_static_111 AVG POWER FROM=145300ps TO=145600ps
.MEASURE TRAN P_static_112 AVG POWER FROM=146600ps TO=146900ps
.MEASURE TRAN P_static_113 AVG POWER FROM=147900ps TO=148200ps
.MEASURE TRAN P_static_114 AVG POWER FROM=149200ps TO=149500ps
.MEASURE TRAN P_static_115 AVG POWER FROM=150500ps TO=150800ps
.MEASURE TRAN P_static_116 AVG POWER FROM=151800ps TO=152100ps
.MEASURE TRAN P_static_117 AVG POWER FROM=153100ps TO=153400ps
.MEASURE TRAN P_static_118 AVG POWER FROM=154400ps TO=154700ps
.MEASURE TRAN P_static_119 AVG POWER FROM=155700ps TO=156000ps
.MEASURE TRAN P_static_120 AVG POWER FROM=157000ps TO=157300ps
.MEASURE TRAN P_static_121 AVG POWER FROM=158300ps TO=158600ps
.MEASURE TRAN P_static_122 AVG POWER FROM=159600ps TO=159900ps
.MEASURE TRAN P_static_123 AVG POWER FROM=160900ps TO=161200ps
.MEASURE TRAN P_static_124 AVG POWER FROM=162200ps TO=162500ps
.MEASURE TRAN P_static_125 AVG POWER FROM=163500ps TO=163800ps
.MEASURE TRAN P_static_126 AVG POWER FROM=164800ps TO=165100ps
.MEASURE TRAN P_static_127 AVG POWER FROM=166100ps TO=166400ps
.MEASURE TRAN P_static_128 AVG POWER FROM=167400ps TO=167700ps
.MEASURE TRAN P_static_129 AVG POWER FROM=168700ps TO=169000ps
.MEASURE TRAN P_static_130 AVG POWER FROM=170000ps TO=170300ps
.MEASURE TRAN P_static_131 AVG POWER FROM=171300ps TO=171600ps
.MEASURE TRAN P_static_132 AVG POWER FROM=172600ps TO=172900ps
.MEASURE TRAN P_static_133 AVG POWER FROM=173900ps TO=174200ps
.MEASURE TRAN P_static_134 AVG POWER FROM=175200ps TO=175500ps
.MEASURE TRAN P_static_135 AVG POWER FROM=176500ps TO=176800ps
.MEASURE TRAN P_static_136 AVG POWER FROM=177800ps TO=178100ps
.MEASURE TRAN P_static_137 AVG POWER FROM=179100ps TO=179400ps
.MEASURE TRAN P_static_138 AVG POWER FROM=180400ps TO=180700ps
.MEASURE TRAN P_static_139 AVG POWER FROM=181700ps TO=182000ps
.MEASURE TRAN P_static_140 AVG POWER FROM=183000ps TO=183300ps
.MEASURE TRAN P_static_141 AVG POWER FROM=184300ps TO=184600ps
.MEASURE TRAN P_static_142 AVG POWER FROM=185600ps TO=185900ps
.MEASURE TRAN P_static_143 AVG POWER FROM=186900ps TO=187200ps
.MEASURE TRAN P_static_144 AVG POWER FROM=188200ps TO=188500ps
.MEASURE TRAN P_static_145 AVG POWER FROM=189500ps TO=189800ps
.MEASURE TRAN P_static_146 AVG POWER FROM=190800ps TO=191100ps
.MEASURE TRAN P_static_147 AVG POWER FROM=192100ps TO=192400ps
.MEASURE TRAN P_static_148 AVG POWER FROM=193400ps TO=193700ps
.MEASURE TRAN P_static_149 AVG POWER FROM=194700ps TO=195000ps
.MEASURE TRAN P_static_150 AVG POWER FROM=196000ps TO=196300ps
.MEASURE TRAN P_static_151 AVG POWER FROM=197300ps TO=197600ps
.MEASURE TRAN P_static_152 AVG POWER FROM=198600ps TO=198900ps
.MEASURE TRAN P_static_153 AVG POWER FROM=199900ps TO=200200ps
.MEASURE TRAN P_static_154 AVG POWER FROM=201200ps TO=201500ps
.MEASURE TRAN P_static_155 AVG POWER FROM=202500ps TO=202800ps
.MEASURE TRAN P_static_156 AVG POWER FROM=203800ps TO=204100ps
.MEASURE TRAN P_static_157 AVG POWER FROM=205100ps TO=205400ps
.MEASURE TRAN P_static_158 AVG POWER FROM=206400ps TO=206700ps
.MEASURE TRAN P_static_159 AVG POWER FROM=207700ps TO=208000ps
.MEASURE TRAN P_static_160 AVG POWER FROM=209000ps TO=209300ps
.MEASURE TRAN P_static_161 AVG POWER FROM=210300ps TO=210600ps
.MEASURE TRAN P_static_162 AVG POWER FROM=211600ps TO=211900ps
.MEASURE TRAN P_static_163 AVG POWER FROM=212900ps TO=213200ps
.MEASURE TRAN P_static_164 AVG POWER FROM=214200ps TO=214500ps
.MEASURE TRAN P_static_165 AVG POWER FROM=215500ps TO=215800ps
.MEASURE TRAN P_static_166 AVG POWER FROM=216800ps TO=217100ps
.MEASURE TRAN P_static_167 AVG POWER FROM=218100ps TO=218400ps
.MEASURE TRAN P_static_168 AVG POWER FROM=219400ps TO=219700ps
.MEASURE TRAN P_static_169 AVG POWER FROM=220700ps TO=221000ps
.MEASURE TRAN P_static_170 AVG POWER FROM=222000ps TO=222300ps
.MEASURE TRAN P_static_171 AVG POWER FROM=223300ps TO=223600ps
.MEASURE TRAN P_static_172 AVG POWER FROM=224600ps TO=224900ps
.MEASURE TRAN P_static_173 AVG POWER FROM=225900ps TO=226200ps
.MEASURE TRAN P_static_174 AVG POWER FROM=227200ps TO=227500ps
.MEASURE TRAN P_static_175 AVG POWER FROM=228500ps TO=228800ps
.MEASURE TRAN P_static_176 AVG POWER FROM=229800ps TO=230100ps
.MEASURE TRAN P_static_177 AVG POWER FROM=231100ps TO=231400ps
.MEASURE TRAN P_static_178 AVG POWER FROM=232400ps TO=232700ps
.MEASURE TRAN P_static_179 AVG POWER FROM=233700ps TO=234000ps
.MEASURE TRAN P_static_180 AVG POWER FROM=235000ps TO=235300ps
.MEASURE TRAN P_static_181 AVG POWER FROM=236300ps TO=236600ps
.MEASURE TRAN P_static_182 AVG POWER FROM=237600ps TO=237900ps
.MEASURE TRAN P_static_183 AVG POWER FROM=238900ps TO=239200ps
.MEASURE TRAN P_static_184 AVG POWER FROM=240200ps TO=240500ps
.MEASURE TRAN P_static_185 AVG POWER FROM=241500ps TO=241800ps
.MEASURE TRAN P_static_186 AVG POWER FROM=242800ps TO=243100ps
.MEASURE TRAN P_static_187 AVG POWER FROM=244100ps TO=244400ps
.MEASURE TRAN P_static_188 AVG POWER FROM=245400ps TO=245700ps
.MEASURE TRAN P_static_189 AVG POWER FROM=246700ps TO=247000ps
.MEASURE TRAN P_static_190 AVG POWER FROM=248000ps TO=248300ps
.MEASURE TRAN P_static_191 AVG POWER FROM=249300ps TO=249600ps
.MEASURE TRAN P_static_192 AVG POWER FROM=250600ps TO=250900ps
.MEASURE TRAN P_static_193 AVG POWER FROM=251900ps TO=252200ps
.MEASURE TRAN P_static_194 AVG POWER FROM=253200ps TO=253500ps
.MEASURE TRAN P_static_195 AVG POWER FROM=254500ps TO=254800ps
.MEASURE TRAN P_static_196 AVG POWER FROM=255800ps TO=256100ps
.MEASURE TRAN P_static_197 AVG POWER FROM=257100ps TO=257400ps
.MEASURE TRAN P_static_198 AVG POWER FROM=258400ps TO=258700ps
.MEASURE TRAN P_static_199 AVG POWER FROM=259700ps TO=260000ps
.MEASURE TRAN P_static_200 AVG POWER FROM=261000ps TO=261300ps
.MEASURE TRAN P_static_201 AVG POWER FROM=262300ps TO=262600ps
.MEASURE TRAN P_static_202 AVG POWER FROM=263600ps TO=263900ps
.MEASURE TRAN P_static_203 AVG POWER FROM=264900ps TO=265200ps
.MEASURE TRAN P_static_204 AVG POWER FROM=266200ps TO=266500ps
.MEASURE TRAN P_static_205 AVG POWER FROM=267500ps TO=267800ps
.MEASURE TRAN P_static_206 AVG POWER FROM=268800ps TO=269100ps
.MEASURE TRAN P_static_207 AVG POWER FROM=270100ps TO=270400ps
.MEASURE TRAN P_static_208 AVG POWER FROM=271400ps TO=271700ps
.MEASURE TRAN P_static_209 AVG POWER FROM=272700ps TO=273000ps
.MEASURE TRAN P_static_210 AVG POWER FROM=274000ps TO=274300ps
.MEASURE TRAN P_static_211 AVG POWER FROM=275300ps TO=275600ps
.MEASURE TRAN P_static_212 AVG POWER FROM=276600ps TO=276900ps
.MEASURE TRAN P_static_213 AVG POWER FROM=277900ps TO=278200ps
.MEASURE TRAN P_static_214 AVG POWER FROM=279200ps TO=279500ps
.MEASURE TRAN P_static_215 AVG POWER FROM=280500ps TO=280800ps
.MEASURE TRAN P_static_216 AVG POWER FROM=281800ps TO=282100ps
.MEASURE TRAN P_static_217 AVG POWER FROM=283100ps TO=283400ps
.MEASURE TRAN P_static_218 AVG POWER FROM=284400ps TO=284700ps
.MEASURE TRAN P_static_219 AVG POWER FROM=285700ps TO=286000ps
.MEASURE TRAN P_static_220 AVG POWER FROM=287000ps TO=287300ps
.MEASURE TRAN P_static_221 AVG POWER FROM=288300ps TO=288600ps
.MEASURE TRAN P_static_222 AVG POWER FROM=289600ps TO=289900ps
.MEASURE TRAN P_static_223 AVG POWER FROM=290900ps TO=291200ps
.MEASURE TRAN P_static_224 AVG POWER FROM=292200ps TO=292500ps
.MEASURE TRAN P_static_225 AVG POWER FROM=293500ps TO=293800ps
.MEASURE TRAN P_static_226 AVG POWER FROM=294800ps TO=295100ps
.MEASURE TRAN P_static_227 AVG POWER FROM=296100ps TO=296400ps
.MEASURE TRAN P_static_228 AVG POWER FROM=297400ps TO=297700ps
.MEASURE TRAN P_static_229 AVG POWER FROM=298700ps TO=299000ps
.MEASURE TRAN P_static_230 AVG POWER FROM=300000ps TO=300300ps
.MEASURE TRAN P_static_231 AVG POWER FROM=301300ps TO=301600ps
.MEASURE TRAN P_static_232 AVG POWER FROM=302600ps TO=302900ps
.MEASURE TRAN P_static_233 AVG POWER FROM=303900ps TO=304200ps
.MEASURE TRAN P_static_234 AVG POWER FROM=305200ps TO=305500ps
.MEASURE TRAN P_static_235 AVG POWER FROM=306500ps TO=306800ps
.MEASURE TRAN P_static_236 AVG POWER FROM=307800ps TO=308100ps
.MEASURE TRAN P_static_237 AVG POWER FROM=309100ps TO=309400ps
.MEASURE TRAN P_static_238 AVG POWER FROM=310400ps TO=310700ps
.MEASURE TRAN P_static_239 AVG POWER FROM=311700ps TO=312000ps
.MEASURE TRAN P_static_240 AVG POWER FROM=313000ps TO=313300ps
.MEASURE TRAN P_static_241 AVG POWER FROM=314300ps TO=314600ps
.MEASURE TRAN P_static_242 AVG POWER FROM=315600ps TO=315900ps
.MEASURE TRAN P_static_243 AVG POWER FROM=316900ps TO=317200ps
.MEASURE TRAN P_static_244 AVG POWER FROM=318200ps TO=318500ps
.MEASURE TRAN P_static_245 AVG POWER FROM=319500ps TO=319800ps
.MEASURE TRAN P_static_246 AVG POWER FROM=320800ps TO=321100ps
.MEASURE TRAN P_static_247 AVG POWER FROM=322100ps TO=322400ps
.MEASURE TRAN P_static_248 AVG POWER FROM=323400ps TO=323700ps
.MEASURE TRAN P_static_249 AVG POWER FROM=324700ps TO=325000ps
.MEASURE TRAN P_static_250 AVG POWER FROM=326000ps TO=326300ps
.MEASURE TRAN P_static_251 AVG POWER FROM=327300ps TO=327600ps
.MEASURE TRAN P_static_252 AVG POWER FROM=328600ps TO=328900ps
.MEASURE TRAN P_static_253 AVG POWER FROM=329900ps TO=330200ps
.MEASURE TRAN P_static_254 AVG POWER FROM=331200ps TO=331500ps
.MEASURE TRAN P_static_255 AVG POWER FROM=332500ps TO=332800ps
.MEASURE TRAN P_static_256 AVG POWER FROM=333800ps TO=334100ps
.MEASURE TRAN P_static_257 AVG POWER FROM=335100ps TO=335400ps
.MEASURE TRAN P_static_258 AVG POWER FROM=336400ps TO=336700ps
.MEASURE TRAN P_static_259 AVG POWER FROM=337700ps TO=338000ps
.MEASURE TRAN P_static_260 AVG POWER FROM=339000ps TO=339300ps
.MEASURE TRAN P_static_261 AVG POWER FROM=340300ps TO=340600ps
.MEASURE TRAN P_static_262 AVG POWER FROM=341600ps TO=341900ps
.MEASURE TRAN P_static_263 AVG POWER FROM=342900ps TO=343200ps
.MEASURE TRAN P_static_264 AVG POWER FROM=344200ps TO=344500ps
.MEASURE TRAN P_static_265 AVG POWER FROM=345500ps TO=345800ps
.MEASURE TRAN P_static_266 AVG POWER FROM=346800ps TO=347100ps
.MEASURE TRAN P_static_267 AVG POWER FROM=348100ps TO=348400ps
.MEASURE TRAN P_static_268 AVG POWER FROM=349400ps TO=349700ps
.MEASURE TRAN P_static_269 AVG POWER FROM=350700ps TO=351000ps
.MEASURE TRAN P_static_270 AVG POWER FROM=352000ps TO=352300ps
.MEASURE TRAN P_static_271 AVG POWER FROM=353300ps TO=353600ps
.MEASURE TRAN P_static_272 AVG POWER FROM=354600ps TO=354900ps
.MEASURE TRAN P_static_273 AVG POWER FROM=355900ps TO=356200ps
.MEASURE TRAN P_static_274 AVG POWER FROM=357200ps TO=357500ps
.MEASURE TRAN P_static_275 AVG POWER FROM=358500ps TO=358800ps
.MEASURE TRAN P_static_276 AVG POWER FROM=359800ps TO=360100ps
.MEASURE TRAN P_static_277 AVG POWER FROM=361100ps TO=361400ps
.MEASURE TRAN P_static_278 AVG POWER FROM=362400ps TO=362700ps
.MEASURE TRAN P_static_279 AVG POWER FROM=363700ps TO=364000ps
.MEASURE TRAN P_static_280 AVG POWER FROM=365000ps TO=365300ps
.MEASURE TRAN P_static_281 AVG POWER FROM=366300ps TO=366600ps
.MEASURE TRAN P_static_282 AVG POWER FROM=367600ps TO=367900ps
.MEASURE TRAN P_static_283 AVG POWER FROM=368900ps TO=369200ps
.MEASURE TRAN P_static_284 AVG POWER FROM=370200ps TO=370500ps
.MEASURE TRAN P_static_285 AVG POWER FROM=371500ps TO=371800ps
.MEASURE TRAN P_static_286 AVG POWER FROM=372800ps TO=373100ps
.MEASURE TRAN P_static_287 AVG POWER FROM=374100ps TO=374400ps
.MEASURE TRAN P_static_288 AVG POWER FROM=375400ps TO=375700ps
.MEASURE TRAN P_static_289 AVG POWER FROM=376700ps TO=377000ps
.MEASURE TRAN P_static_290 AVG POWER FROM=378000ps TO=378300ps
.MEASURE TRAN P_static_291 AVG POWER FROM=379300ps TO=379600ps
.MEASURE TRAN P_static_292 AVG POWER FROM=380600ps TO=380900ps
.MEASURE TRAN P_static_293 AVG POWER FROM=381900ps TO=382200ps
.MEASURE TRAN P_static_294 AVG POWER FROM=383200ps TO=383500ps
.MEASURE TRAN P_static_295 AVG POWER FROM=384500ps TO=384800ps
.MEASURE TRAN P_static_296 AVG POWER FROM=385800ps TO=386100ps
.MEASURE TRAN P_static_297 AVG POWER FROM=387100ps TO=387400ps
.MEASURE TRAN P_static_298 AVG POWER FROM=388400ps TO=388700ps
.MEASURE TRAN P_static_299 AVG POWER FROM=389700ps TO=390000ps
.MEASURE TRAN P_static_300 AVG POWER FROM=391000ps TO=391300ps
.MEASURE TRAN P_static_301 AVG POWER FROM=392300ps TO=392600ps
.MEASURE TRAN P_static_302 AVG POWER FROM=393600ps TO=393900ps
.MEASURE TRAN P_static_303 AVG POWER FROM=394900ps TO=395200ps
.MEASURE TRAN P_static_304 AVG POWER FROM=396200ps TO=396500ps
.MEASURE TRAN P_static_305 AVG POWER FROM=397500ps TO=397800ps
.MEASURE TRAN P_static_306 AVG POWER FROM=398800ps TO=399100ps
.MEASURE TRAN P_static_307 AVG POWER FROM=400100ps TO=400400ps
.MEASURE TRAN P_static_308 AVG POWER FROM=401400ps TO=401700ps
.MEASURE TRAN P_static_309 AVG POWER FROM=402700ps TO=403000ps
.MEASURE TRAN P_static_310 AVG POWER FROM=404000ps TO=404300ps
.MEASURE TRAN P_static_311 AVG POWER FROM=405300ps TO=405600ps
.MEASURE TRAN P_static_312 AVG POWER FROM=406600ps TO=406900ps
.MEASURE TRAN P_static_313 AVG POWER FROM=407900ps TO=408200ps
.MEASURE TRAN P_static_314 AVG POWER FROM=409200ps TO=409500ps
.MEASURE TRAN P_static_315 AVG POWER FROM=410500ps TO=410800ps
.MEASURE TRAN P_static_316 AVG POWER FROM=411800ps TO=412100ps
.MEASURE TRAN P_static_317 AVG POWER FROM=413100ps TO=413400ps
.MEASURE TRAN P_static_318 AVG POWER FROM=414400ps TO=414700ps
.MEASURE TRAN P_static_319 AVG POWER FROM=415700ps TO=416000ps
.MEASURE TRAN P_static_320 AVG POWER FROM=417000ps TO=417300ps
.MEASURE TRAN P_static_321 AVG POWER FROM=418300ps TO=418600ps
.MEASURE TRAN P_static_322 AVG POWER FROM=419600ps TO=419900ps
.MEASURE TRAN P_static_323 AVG POWER FROM=420900ps TO=421200ps
.MEASURE TRAN P_static_324 AVG POWER FROM=422200ps TO=422500ps
.MEASURE TRAN P_static_325 AVG POWER FROM=423500ps TO=423800ps
.MEASURE TRAN P_static_326 AVG POWER FROM=424800ps TO=425100ps
.MEASURE TRAN P_static_327 AVG POWER FROM=426100ps TO=426400ps
.MEASURE TRAN P_static_328 AVG POWER FROM=427400ps TO=427700ps
.MEASURE TRAN P_static_329 AVG POWER FROM=428700ps TO=429000ps
.MEASURE TRAN P_static_330 AVG POWER FROM=430000ps TO=430300ps
.MEASURE TRAN P_static_331 AVG POWER FROM=431300ps TO=431600ps
.MEASURE TRAN P_static_332 AVG POWER FROM=432600ps TO=432900ps
.MEASURE TRAN P_static_333 AVG POWER FROM=433900ps TO=434200ps
.MEASURE TRAN P_static_334 AVG POWER FROM=435200ps TO=435500ps
.MEASURE TRAN P_static_335 AVG POWER FROM=436500ps TO=436800ps
.MEASURE TRAN P_static_336 AVG POWER FROM=437800ps TO=438100ps
.MEASURE TRAN P_static_337 AVG POWER FROM=439100ps TO=439400ps
.MEASURE TRAN P_static_338 AVG POWER FROM=440400ps TO=440700ps
.MEASURE TRAN P_static_339 AVG POWER FROM=441700ps TO=442000ps
.MEASURE TRAN P_static_340 AVG POWER FROM=443000ps TO=443300ps
.MEASURE TRAN P_static_341 AVG POWER FROM=444300ps TO=444600ps
.MEASURE TRAN P_static_342 AVG POWER FROM=445600ps TO=445900ps
.MEASURE TRAN P_static_343 AVG POWER FROM=446900ps TO=447200ps
.MEASURE TRAN P_static_344 AVG POWER FROM=448200ps TO=448500ps
.MEASURE TRAN P_static_345 AVG POWER FROM=449500ps TO=449800ps
.MEASURE TRAN P_static_346 AVG POWER FROM=450800ps TO=451100ps
.MEASURE TRAN P_static_347 AVG POWER FROM=452100ps TO=452400ps
.MEASURE TRAN P_static_348 AVG POWER FROM=453400ps TO=453700ps
.MEASURE TRAN P_static_349 AVG POWER FROM=454700ps TO=455000ps
.MEASURE TRAN P_static_350 AVG POWER FROM=456000ps TO=456300ps
.MEASURE TRAN P_static_351 AVG POWER FROM=457300ps TO=457600ps
.MEASURE TRAN P_static_352 AVG POWER FROM=458600ps TO=458900ps
.MEASURE TRAN P_static_353 AVG POWER FROM=459900ps TO=460200ps
.MEASURE TRAN P_static_354 AVG POWER FROM=461200ps TO=461500ps
.MEASURE TRAN P_static_355 AVG POWER FROM=462500ps TO=462800ps
.MEASURE TRAN P_static_356 AVG POWER FROM=463800ps TO=464100ps
.MEASURE TRAN P_static_357 AVG POWER FROM=465100ps TO=465400ps
.MEASURE TRAN P_static_358 AVG POWER FROM=466400ps TO=466700ps
.MEASURE TRAN P_static_359 AVG POWER FROM=467700ps TO=468000ps
.MEASURE TRAN P_static_360 AVG POWER FROM=469000ps TO=469300ps
.MEASURE TRAN P_static_361 AVG POWER FROM=470300ps TO=470600ps
.MEASURE TRAN P_static_362 AVG POWER FROM=471600ps TO=471900ps
.MEASURE TRAN P_static_363 AVG POWER FROM=472900ps TO=473200ps
.MEASURE TRAN P_static_364 AVG POWER FROM=474200ps TO=474500ps
.MEASURE TRAN P_static_365 AVG POWER FROM=475500ps TO=475800ps
.MEASURE TRAN P_static_366 AVG POWER FROM=476800ps TO=477100ps
.MEASURE TRAN P_static_367 AVG POWER FROM=478100ps TO=478400ps
.MEASURE TRAN P_static_368 AVG POWER FROM=479400ps TO=479700ps
.MEASURE TRAN P_static_369 AVG POWER FROM=480700ps TO=481000ps
.MEASURE TRAN P_static_370 AVG POWER FROM=482000ps TO=482300ps
.MEASURE TRAN P_static_371 AVG POWER FROM=483300ps TO=483600ps
.MEASURE TRAN P_static_372 AVG POWER FROM=484600ps TO=484900ps
.MEASURE TRAN P_static_373 AVG POWER FROM=485900ps TO=486200ps
.MEASURE TRAN P_static_374 AVG POWER FROM=487200ps TO=487500ps
.MEASURE TRAN P_static_375 AVG POWER FROM=488500ps TO=488800ps
.MEASURE TRAN P_static_376 AVG POWER FROM=489800ps TO=490100ps
.MEASURE TRAN P_static_377 AVG POWER FROM=491100ps TO=491400ps
.MEASURE TRAN P_static_378 AVG POWER FROM=492400ps TO=492700ps
.MEASURE TRAN P_static_379 AVG POWER FROM=493700ps TO=494000ps
.MEASURE TRAN P_static_380 AVG POWER FROM=495000ps TO=495300ps
.MEASURE TRAN P_static_381 AVG POWER FROM=496300ps TO=496600ps
.MEASURE TRAN P_static_382 AVG POWER FROM=497600ps TO=497900ps
.MEASURE TRAN P_static_383 AVG POWER FROM=498900ps TO=499200ps
.MEASURE TRAN P_static_384 AVG POWER FROM=500200ps TO=500500ps
.MEASURE TRAN P_static_385 AVG POWER FROM=501500ps TO=501800ps
.MEASURE TRAN P_static_386 AVG POWER FROM=502800ps TO=503100ps
.MEASURE TRAN P_static_387 AVG POWER FROM=504100ps TO=504400ps
.MEASURE TRAN P_static_388 AVG POWER FROM=505400ps TO=505700ps
.MEASURE TRAN P_static_389 AVG POWER FROM=506700ps TO=507000ps
.MEASURE TRAN P_static_390 AVG POWER FROM=508000ps TO=508300ps
.MEASURE TRAN P_static_391 AVG POWER FROM=509300ps TO=509600ps
.MEASURE TRAN P_static_392 AVG POWER FROM=510600ps TO=510900ps
.MEASURE TRAN P_static_393 AVG POWER FROM=511900ps TO=512200ps
.MEASURE TRAN P_static_394 AVG POWER FROM=513200ps TO=513500ps
.MEASURE TRAN P_static_395 AVG POWER FROM=514500ps TO=514800ps
.MEASURE TRAN P_static_396 AVG POWER FROM=515800ps TO=516100ps
.MEASURE TRAN P_static_397 AVG POWER FROM=517100ps TO=517400ps
.MEASURE TRAN P_static_398 AVG POWER FROM=518400ps TO=518700ps
.MEASURE TRAN P_static_399 AVG POWER FROM=519700ps TO=520000ps
.MEASURE TRAN P_static_400 AVG POWER FROM=521000ps TO=521300ps
.MEASURE TRAN P_static_401 AVG POWER FROM=522300ps TO=522600ps
.MEASURE TRAN P_static_402 AVG POWER FROM=523600ps TO=523900ps
.MEASURE TRAN P_static_403 AVG POWER FROM=524900ps TO=525200ps
.MEASURE TRAN P_static_404 AVG POWER FROM=526200ps TO=526500ps
.MEASURE TRAN P_static_405 AVG POWER FROM=527500ps TO=527800ps
.MEASURE TRAN P_static_406 AVG POWER FROM=528800ps TO=529100ps
.MEASURE TRAN P_static_407 AVG POWER FROM=530100ps TO=530400ps
.MEASURE TRAN P_static_408 AVG POWER FROM=531400ps TO=531700ps
.MEASURE TRAN P_static_409 AVG POWER FROM=532700ps TO=533000ps
.MEASURE TRAN P_static_410 AVG POWER FROM=534000ps TO=534300ps
.MEASURE TRAN P_static_411 AVG POWER FROM=535300ps TO=535600ps
.MEASURE TRAN P_static_412 AVG POWER FROM=536600ps TO=536900ps
.MEASURE TRAN P_static_413 AVG POWER FROM=537900ps TO=538200ps
.MEASURE TRAN P_static_414 AVG POWER FROM=539200ps TO=539500ps
.MEASURE TRAN P_static_415 AVG POWER FROM=540500ps TO=540800ps
.MEASURE TRAN P_static_416 AVG POWER FROM=541800ps TO=542100ps
.MEASURE TRAN P_static_417 AVG POWER FROM=543100ps TO=543400ps
.MEASURE TRAN P_static_418 AVG POWER FROM=544400ps TO=544700ps
.MEASURE TRAN P_static_419 AVG POWER FROM=545700ps TO=546000ps
.MEASURE TRAN P_static_420 AVG POWER FROM=547000ps TO=547300ps
.MEASURE TRAN P_static_421 AVG POWER FROM=548300ps TO=548600ps
.MEASURE TRAN P_static_422 AVG POWER FROM=549600ps TO=549900ps
.MEASURE TRAN P_static_423 AVG POWER FROM=550900ps TO=551200ps
.MEASURE TRAN P_static_424 AVG POWER FROM=552200ps TO=552500ps
.MEASURE TRAN P_static_425 AVG POWER FROM=553500ps TO=553800ps
.MEASURE TRAN P_static_426 AVG POWER FROM=554800ps TO=555100ps
.MEASURE TRAN P_static_427 AVG POWER FROM=556100ps TO=556400ps
.MEASURE TRAN P_static_428 AVG POWER FROM=557400ps TO=557700ps
.MEASURE TRAN P_static_429 AVG POWER FROM=558700ps TO=559000ps
.MEASURE TRAN P_static_430 AVG POWER FROM=560000ps TO=560300ps
.MEASURE TRAN P_static_431 AVG POWER FROM=561300ps TO=561600ps
.MEASURE TRAN P_static_432 AVG POWER FROM=562600ps TO=562900ps
.MEASURE TRAN P_static_433 AVG POWER FROM=563900ps TO=564200ps
.MEASURE TRAN P_static_434 AVG POWER FROM=565200ps TO=565500ps
.MEASURE TRAN P_static_435 AVG POWER FROM=566500ps TO=566800ps
.MEASURE TRAN P_static_436 AVG POWER FROM=567800ps TO=568100ps
.MEASURE TRAN P_static_437 AVG POWER FROM=569100ps TO=569400ps
.MEASURE TRAN P_static_438 AVG POWER FROM=570400ps TO=570700ps
.MEASURE TRAN P_static_439 AVG POWER FROM=571700ps TO=572000ps
.MEASURE TRAN P_static_440 AVG POWER FROM=573000ps TO=573300ps
.MEASURE TRAN P_static_441 AVG POWER FROM=574300ps TO=574600ps
.MEASURE TRAN P_static_442 AVG POWER FROM=575600ps TO=575900ps
.MEASURE TRAN P_static_443 AVG POWER FROM=576900ps TO=577200ps
.MEASURE TRAN P_static_444 AVG POWER FROM=578200ps TO=578500ps
.MEASURE TRAN P_static_445 AVG POWER FROM=579500ps TO=579800ps
.MEASURE TRAN P_static_446 AVG POWER FROM=580800ps TO=581100ps
.MEASURE TRAN P_static_447 AVG POWER FROM=582100ps TO=582400ps
.MEASURE TRAN P_static_448 AVG POWER FROM=583400ps TO=583700ps
.MEASURE TRAN P_static_449 AVG POWER FROM=584700ps TO=585000ps
.MEASURE TRAN P_static_450 AVG POWER FROM=586000ps TO=586300ps
.MEASURE TRAN P_static_451 AVG POWER FROM=587300ps TO=587600ps
.MEASURE TRAN P_static_452 AVG POWER FROM=588600ps TO=588900ps
.MEASURE TRAN P_static_453 AVG POWER FROM=589900ps TO=590200ps
.MEASURE TRAN P_static_454 AVG POWER FROM=591200ps TO=591500ps
.MEASURE TRAN P_static_455 AVG POWER FROM=592500ps TO=592800ps
.MEASURE TRAN P_static_456 AVG POWER FROM=593800ps TO=594100ps
.MEASURE TRAN P_static_457 AVG POWER FROM=595100ps TO=595400ps
.MEASURE TRAN P_static_458 AVG POWER FROM=596400ps TO=596700ps
.MEASURE TRAN P_static_459 AVG POWER FROM=597700ps TO=598000ps
.MEASURE TRAN P_static_460 AVG POWER FROM=599000ps TO=599300ps
.MEASURE TRAN P_static_461 AVG POWER FROM=600300ps TO=600600ps
.MEASURE TRAN P_static_462 AVG POWER FROM=601600ps TO=601900ps
.MEASURE TRAN P_static_463 AVG POWER FROM=602900ps TO=603200ps
.MEASURE TRAN P_static_464 AVG POWER FROM=604200ps TO=604500ps
.MEASURE TRAN P_static_465 AVG POWER FROM=605500ps TO=605800ps
.MEASURE TRAN P_static_466 AVG POWER FROM=606800ps TO=607100ps
.MEASURE TRAN P_static_467 AVG POWER FROM=608100ps TO=608400ps
.MEASURE TRAN P_static_468 AVG POWER FROM=609400ps TO=609700ps
.MEASURE TRAN P_static_469 AVG POWER FROM=610700ps TO=611000ps
.MEASURE TRAN P_static_470 AVG POWER FROM=612000ps TO=612300ps
.MEASURE TRAN P_static_471 AVG POWER FROM=613300ps TO=613600ps
.MEASURE TRAN P_static_472 AVG POWER FROM=614600ps TO=614900ps
.MEASURE TRAN P_static_473 AVG POWER FROM=615900ps TO=616200ps
.MEASURE TRAN P_static_474 AVG POWER FROM=617200ps TO=617500ps
.MEASURE TRAN P_static_475 AVG POWER FROM=618500ps TO=618800ps
.MEASURE TRAN P_static_476 AVG POWER FROM=619800ps TO=620100ps
.MEASURE TRAN P_static_477 AVG POWER FROM=621100ps TO=621400ps
.MEASURE TRAN P_static_478 AVG POWER FROM=622400ps TO=622700ps
.MEASURE TRAN P_static_479 AVG POWER FROM=623700ps TO=624000ps
.MEASURE TRAN P_static_480 AVG POWER FROM=625000ps TO=625300ps
.MEASURE TRAN P_static_481 AVG POWER FROM=626300ps TO=626600ps
.MEASURE TRAN P_static_482 AVG POWER FROM=627600ps TO=627900ps
.MEASURE TRAN P_static_483 AVG POWER FROM=628900ps TO=629200ps
.MEASURE TRAN P_static_484 AVG POWER FROM=630200ps TO=630500ps
.MEASURE TRAN P_static_485 AVG POWER FROM=631500ps TO=631800ps
.MEASURE TRAN P_static_486 AVG POWER FROM=632800ps TO=633100ps
.MEASURE TRAN P_static_487 AVG POWER FROM=634100ps TO=634400ps
.MEASURE TRAN P_static_488 AVG POWER FROM=635400ps TO=635700ps
.MEASURE TRAN P_static_489 AVG POWER FROM=636700ps TO=637000ps
.MEASURE TRAN P_static_490 AVG POWER FROM=638000ps TO=638300ps
.MEASURE TRAN P_static_491 AVG POWER FROM=639300ps TO=639600ps
.MEASURE TRAN P_static_492 AVG POWER FROM=640600ps TO=640900ps
.MEASURE TRAN P_static_493 AVG POWER FROM=641900ps TO=642200ps
.MEASURE TRAN P_static_494 AVG POWER FROM=643200ps TO=643500ps
.MEASURE TRAN P_static_495 AVG POWER FROM=644500ps TO=644800ps
.MEASURE TRAN P_static_496 AVG POWER FROM=645800ps TO=646100ps
.MEASURE TRAN P_static_497 AVG POWER FROM=647100ps TO=647400ps
.MEASURE TRAN P_static_498 AVG POWER FROM=648400ps TO=648700ps
.MEASURE TRAN P_static_499 AVG POWER FROM=649700ps TO=650000ps
.MEASURE TRAN P_static_500 AVG POWER FROM=651000ps TO=651300ps
.MEASURE TRAN P_static_501 AVG POWER FROM=652300ps TO=652600ps
.MEASURE TRAN P_static_502 AVG POWER FROM=653600ps TO=653900ps
.MEASURE TRAN P_static_503 AVG POWER FROM=654900ps TO=655200ps
.MEASURE TRAN P_static_504 AVG POWER FROM=656200ps TO=656500ps
.MEASURE TRAN P_static_505 AVG POWER FROM=657500ps TO=657800ps
.MEASURE TRAN P_static_506 AVG POWER FROM=658800ps TO=659100ps
.MEASURE TRAN P_static_507 AVG POWER FROM=660100ps TO=660400ps
.MEASURE TRAN P_static_508 AVG POWER FROM=661400ps TO=661700ps
.MEASURE TRAN P_static_509 AVG POWER FROM=662700ps TO=663000ps
.MEASURE TRAN P_static_510 AVG POWER FROM=664000ps TO=664300ps
.MEASURE TRAN P_static_511 AVG POWER FROM=665300ps TO=665600ps
.MEASURE TRAN P_static_512 AVG POWER FROM=666600ps TO=666900ps
.MEASURE TRAN P_static_513 AVG POWER FROM=667900ps TO=668200ps
.MEASURE TRAN P_static_514 AVG POWER FROM=669200ps TO=669500ps
.MEASURE TRAN P_static_515 AVG POWER FROM=670500ps TO=670800ps
.MEASURE TRAN P_static_516 AVG POWER FROM=671800ps TO=672100ps
.MEASURE TRAN P_static_517 AVG POWER FROM=673100ps TO=673400ps
.MEASURE TRAN P_static_518 AVG POWER FROM=674400ps TO=674700ps
.MEASURE TRAN P_static_519 AVG POWER FROM=675700ps TO=676000ps
.MEASURE TRAN P_static_520 AVG POWER FROM=677000ps TO=677300ps
.MEASURE TRAN P_static_521 AVG POWER FROM=678300ps TO=678600ps
.MEASURE TRAN P_static_522 AVG POWER FROM=679600ps TO=679900ps
.MEASURE TRAN P_static_523 AVG POWER FROM=680900ps TO=681200ps
.MEASURE TRAN P_static_524 AVG POWER FROM=682200ps TO=682500ps
.MEASURE TRAN P_static_525 AVG POWER FROM=683500ps TO=683800ps
.MEASURE TRAN P_static_526 AVG POWER FROM=684800ps TO=685100ps
.MEASURE TRAN P_static_527 AVG POWER FROM=686100ps TO=686400ps
.MEASURE TRAN P_static_528 AVG POWER FROM=687400ps TO=687700ps
.MEASURE TRAN P_static_529 AVG POWER FROM=688700ps TO=689000ps
.MEASURE TRAN P_static_530 AVG POWER FROM=690000ps TO=690300ps
.MEASURE TRAN P_static_531 AVG POWER FROM=691300ps TO=691600ps
.MEASURE TRAN P_static_532 AVG POWER FROM=692600ps TO=692900ps
.MEASURE TRAN P_static_533 AVG POWER FROM=693900ps TO=694200ps
.MEASURE TRAN P_static_534 AVG POWER FROM=695200ps TO=695500ps
.MEASURE TRAN P_static_535 AVG POWER FROM=696500ps TO=696800ps
.MEASURE TRAN P_static_536 AVG POWER FROM=697800ps TO=698100ps
.MEASURE TRAN P_static_537 AVG POWER FROM=699100ps TO=699400ps
.MEASURE TRAN P_static_538 AVG POWER FROM=700400ps TO=700700ps
.MEASURE TRAN P_static_539 AVG POWER FROM=701700ps TO=702000ps
.MEASURE TRAN P_static_540 AVG POWER FROM=703000ps TO=703300ps
.MEASURE TRAN P_static_541 AVG POWER FROM=704300ps TO=704600ps
.MEASURE TRAN P_static_542 AVG POWER FROM=705600ps TO=705900ps
.MEASURE TRAN P_static_543 AVG POWER FROM=706900ps TO=707200ps
.MEASURE TRAN P_static_544 AVG POWER FROM=708200ps TO=708500ps
.MEASURE TRAN P_static_545 AVG POWER FROM=709500ps TO=709800ps
.MEASURE TRAN P_static_546 AVG POWER FROM=710800ps TO=711100ps
.MEASURE TRAN P_static_547 AVG POWER FROM=712100ps TO=712400ps
.MEASURE TRAN P_static_548 AVG POWER FROM=713400ps TO=713700ps
.MEASURE TRAN P_static_549 AVG POWER FROM=714700ps TO=715000ps
.MEASURE TRAN P_static_550 AVG POWER FROM=716000ps TO=716300ps
.MEASURE TRAN P_static_551 AVG POWER FROM=717300ps TO=717600ps
.MEASURE TRAN P_static_552 AVG POWER FROM=718600ps TO=718900ps
.MEASURE TRAN P_static_553 AVG POWER FROM=719900ps TO=720200ps
.MEASURE TRAN P_static_554 AVG POWER FROM=721200ps TO=721500ps
.MEASURE TRAN P_static_555 AVG POWER FROM=722500ps TO=722800ps
.MEASURE TRAN P_static_556 AVG POWER FROM=723800ps TO=724100ps
.MEASURE TRAN P_static_557 AVG POWER FROM=725100ps TO=725400ps
.MEASURE TRAN P_static_558 AVG POWER FROM=726400ps TO=726700ps
.MEASURE TRAN P_static_559 AVG POWER FROM=727700ps TO=728000ps
.MEASURE TRAN P_static_560 AVG POWER FROM=729000ps TO=729300ps
.MEASURE TRAN P_static_561 AVG POWER FROM=730300ps TO=730600ps
.MEASURE TRAN P_static_562 AVG POWER FROM=731600ps TO=731900ps
.MEASURE TRAN P_static_563 AVG POWER FROM=732900ps TO=733200ps
.MEASURE TRAN P_static_564 AVG POWER FROM=734200ps TO=734500ps
.MEASURE TRAN P_static_565 AVG POWER FROM=735500ps TO=735800ps
.MEASURE TRAN P_static_566 AVG POWER FROM=736800ps TO=737100ps
.MEASURE TRAN P_static_567 AVG POWER FROM=738100ps TO=738400ps
.MEASURE TRAN P_static_568 AVG POWER FROM=739400ps TO=739700ps
.MEASURE TRAN P_static_569 AVG POWER FROM=740700ps TO=741000ps
.MEASURE TRAN P_static_570 AVG POWER FROM=742000ps TO=742300ps
.MEASURE TRAN P_static_571 AVG POWER FROM=743300ps TO=743600ps
.MEASURE TRAN P_static_572 AVG POWER FROM=744600ps TO=744900ps
.MEASURE TRAN P_static_573 AVG POWER FROM=745900ps TO=746200ps
.MEASURE TRAN P_static_574 AVG POWER FROM=747200ps TO=747500ps
.MEASURE TRAN P_static_575 AVG POWER FROM=748500ps TO=748800ps
.MEASURE TRAN P_static_576 AVG POWER FROM=749800ps TO=750100ps
.MEASURE TRAN P_static_577 AVG POWER FROM=751100ps TO=751400ps
.MEASURE TRAN P_static_578 AVG POWER FROM=752400ps TO=752700ps
.MEASURE TRAN P_static_579 AVG POWER FROM=753700ps TO=754000ps
.MEASURE TRAN P_static_580 AVG POWER FROM=755000ps TO=755300ps
.MEASURE TRAN P_static_581 AVG POWER FROM=756300ps TO=756600ps
.MEASURE TRAN P_static_582 AVG POWER FROM=757600ps TO=757900ps
.MEASURE TRAN P_static_583 AVG POWER FROM=758900ps TO=759200ps
.MEASURE TRAN P_static_584 AVG POWER FROM=760200ps TO=760500ps
.MEASURE TRAN P_static_585 AVG POWER FROM=761500ps TO=761800ps
.MEASURE TRAN P_static_586 AVG POWER FROM=762800ps TO=763100ps
.MEASURE TRAN P_static_587 AVG POWER FROM=764100ps TO=764400ps
.MEASURE TRAN P_static_588 AVG POWER FROM=765400ps TO=765700ps
.MEASURE TRAN P_static_589 AVG POWER FROM=766700ps TO=767000ps
.MEASURE TRAN P_static_590 AVG POWER FROM=768000ps TO=768300ps
.MEASURE TRAN P_static_591 AVG POWER FROM=769300ps TO=769600ps
.MEASURE TRAN P_static_592 AVG POWER FROM=770600ps TO=770900ps
.MEASURE TRAN P_static_593 AVG POWER FROM=771900ps TO=772200ps
.MEASURE TRAN P_static_594 AVG POWER FROM=773200ps TO=773500ps
.MEASURE TRAN P_static_595 AVG POWER FROM=774500ps TO=774800ps
.MEASURE TRAN P_static_596 AVG POWER FROM=775800ps TO=776100ps
.MEASURE TRAN P_static_597 AVG POWER FROM=777100ps TO=777400ps
.MEASURE TRAN P_static_598 AVG POWER FROM=778400ps TO=778700ps
.MEASURE TRAN P_static_599 AVG POWER FROM=779700ps TO=780000ps
.MEASURE TRAN P_static_600 AVG POWER FROM=781000ps TO=781300ps
.MEASURE TRAN P_static_601 AVG POWER FROM=782300ps TO=782600ps
.MEASURE TRAN P_static_602 AVG POWER FROM=783600ps TO=783900ps
.MEASURE TRAN P_static_603 AVG POWER FROM=784900ps TO=785200ps
.MEASURE TRAN P_static_604 AVG POWER FROM=786200ps TO=786500ps
.MEASURE TRAN P_static_605 AVG POWER FROM=787500ps TO=787800ps
.MEASURE TRAN P_static_606 AVG POWER FROM=788800ps TO=789100ps
.MEASURE TRAN P_static_607 AVG POWER FROM=790100ps TO=790400ps
.MEASURE TRAN P_static_608 AVG POWER FROM=791400ps TO=791700ps
.MEASURE TRAN P_static_609 AVG POWER FROM=792700ps TO=793000ps
.MEASURE TRAN P_static_610 AVG POWER FROM=794000ps TO=794300ps
.MEASURE TRAN P_static_611 AVG POWER FROM=795300ps TO=795600ps
.MEASURE TRAN P_static_612 AVG POWER FROM=796600ps TO=796900ps
.MEASURE TRAN P_static_613 AVG POWER FROM=797900ps TO=798200ps
.MEASURE TRAN P_static_614 AVG POWER FROM=799200ps TO=799500ps
.MEASURE TRAN P_static_615 AVG POWER FROM=800500ps TO=800800ps
.MEASURE TRAN P_static_616 AVG POWER FROM=801800ps TO=802100ps
.MEASURE TRAN P_static_617 AVG POWER FROM=803100ps TO=803400ps
.MEASURE TRAN P_static_618 AVG POWER FROM=804400ps TO=804700ps
.MEASURE TRAN P_static_619 AVG POWER FROM=805700ps TO=806000ps
.MEASURE TRAN P_static_620 AVG POWER FROM=807000ps TO=807300ps
.MEASURE TRAN P_static_621 AVG POWER FROM=808300ps TO=808600ps
.MEASURE TRAN P_static_622 AVG POWER FROM=809600ps TO=809900ps
.MEASURE TRAN P_static_623 AVG POWER FROM=810900ps TO=811200ps
.MEASURE TRAN P_static_624 AVG POWER FROM=812200ps TO=812500ps
.MEASURE TRAN P_static_625 AVG POWER FROM=813500ps TO=813800ps
.MEASURE TRAN P_static_626 AVG POWER FROM=814800ps TO=815100ps
.MEASURE TRAN P_static_627 AVG POWER FROM=816100ps TO=816400ps
.MEASURE TRAN P_static_628 AVG POWER FROM=817400ps TO=817700ps
.MEASURE TRAN P_static_629 AVG POWER FROM=818700ps TO=819000ps
.MEASURE TRAN P_static_630 AVG POWER FROM=820000ps TO=820300ps
.MEASURE TRAN P_static_631 AVG POWER FROM=821300ps TO=821600ps
.MEASURE TRAN P_static_632 AVG POWER FROM=822600ps TO=822900ps
.MEASURE TRAN P_static_633 AVG POWER FROM=823900ps TO=824200ps
.MEASURE TRAN P_static_634 AVG POWER FROM=825200ps TO=825500ps
.MEASURE TRAN P_static_635 AVG POWER FROM=826500ps TO=826800ps
.MEASURE TRAN P_static_636 AVG POWER FROM=827800ps TO=828100ps
.MEASURE TRAN P_static_637 AVG POWER FROM=829100ps TO=829400ps
.MEASURE TRAN P_static_638 AVG POWER FROM=830400ps TO=830700ps
.MEASURE TRAN P_static_639 AVG POWER FROM=831700ps TO=832000ps
.MEASURE TRAN P_static_640 AVG POWER FROM=833000ps TO=833300ps
.MEASURE TRAN P_static_641 AVG POWER FROM=834300ps TO=834600ps
.MEASURE TRAN P_static_642 AVG POWER FROM=835600ps TO=835900ps
.MEASURE TRAN P_static_643 AVG POWER FROM=836900ps TO=837200ps
.MEASURE TRAN P_static_644 AVG POWER FROM=838200ps TO=838500ps
.MEASURE TRAN P_static_645 AVG POWER FROM=839500ps TO=839800ps
.MEASURE TRAN P_static_646 AVG POWER FROM=840800ps TO=841100ps
.MEASURE TRAN P_static_647 AVG POWER FROM=842100ps TO=842400ps
.MEASURE TRAN P_static_648 AVG POWER FROM=843400ps TO=843700ps
.MEASURE TRAN P_static_649 AVG POWER FROM=844700ps TO=845000ps
.MEASURE TRAN P_static_650 AVG POWER FROM=846000ps TO=846300ps
.MEASURE TRAN P_static_651 AVG POWER FROM=847300ps TO=847600ps
.MEASURE TRAN P_static_652 AVG POWER FROM=848600ps TO=848900ps
.MEASURE TRAN P_static_653 AVG POWER FROM=849900ps TO=850200ps
.MEASURE TRAN P_static_654 AVG POWER FROM=851200ps TO=851500ps
.MEASURE TRAN P_static_655 AVG POWER FROM=852500ps TO=852800ps
.MEASURE TRAN P_static_656 AVG POWER FROM=853800ps TO=854100ps
.MEASURE TRAN P_static_657 AVG POWER FROM=855100ps TO=855400ps
.MEASURE TRAN P_static_658 AVG POWER FROM=856400ps TO=856700ps
.MEASURE TRAN P_static_659 AVG POWER FROM=857700ps TO=858000ps
.MEASURE TRAN P_static_660 AVG POWER FROM=859000ps TO=859300ps
.MEASURE TRAN P_static_661 AVG POWER FROM=860300ps TO=860600ps
.MEASURE TRAN P_static_662 AVG POWER FROM=861600ps TO=861900ps
.MEASURE TRAN P_static_663 AVG POWER FROM=862900ps TO=863200ps
.MEASURE TRAN P_static_664 AVG POWER FROM=864200ps TO=864500ps
.MEASURE TRAN P_static_665 AVG POWER FROM=865500ps TO=865800ps
.MEASURE TRAN P_static_666 AVG POWER FROM=866800ps TO=867100ps
.MEASURE TRAN P_static_667 AVG POWER FROM=868100ps TO=868400ps
.MEASURE TRAN P_static_668 AVG POWER FROM=869400ps TO=869700ps
.MEASURE TRAN P_static_669 AVG POWER FROM=870700ps TO=871000ps
.MEASURE TRAN P_static_670 AVG POWER FROM=872000ps TO=872300ps
.MEASURE TRAN P_static_671 AVG POWER FROM=873300ps TO=873600ps
.MEASURE TRAN P_static_672 AVG POWER FROM=874600ps TO=874900ps
.MEASURE TRAN P_static_673 AVG POWER FROM=875900ps TO=876200ps
.MEASURE TRAN P_static_674 AVG POWER FROM=877200ps TO=877500ps
.MEASURE TRAN P_static_675 AVG POWER FROM=878500ps TO=878800ps
.MEASURE TRAN P_static_676 AVG POWER FROM=879800ps TO=880100ps
.MEASURE TRAN P_static_677 AVG POWER FROM=881100ps TO=881400ps
.MEASURE TRAN P_static_678 AVG POWER FROM=882400ps TO=882700ps
.MEASURE TRAN P_static_679 AVG POWER FROM=883700ps TO=884000ps
.MEASURE TRAN P_static_680 AVG POWER FROM=885000ps TO=885300ps
.MEASURE TRAN P_static_681 AVG POWER FROM=886300ps TO=886600ps
.MEASURE TRAN P_static_682 AVG POWER FROM=887600ps TO=887900ps
.MEASURE TRAN P_static_683 AVG POWER FROM=888900ps TO=889200ps
.MEASURE TRAN P_static_684 AVG POWER FROM=890200ps TO=890500ps
.MEASURE TRAN P_static_685 AVG POWER FROM=891500ps TO=891800ps
.MEASURE TRAN P_static_686 AVG POWER FROM=892800ps TO=893100ps
.MEASURE TRAN P_static_687 AVG POWER FROM=894100ps TO=894400ps
.MEASURE TRAN P_static_688 AVG POWER FROM=895400ps TO=895700ps
.MEASURE TRAN P_static_689 AVG POWER FROM=896700ps TO=897000ps
.MEASURE TRAN P_static_690 AVG POWER FROM=898000ps TO=898300ps
.MEASURE TRAN P_static_691 AVG POWER FROM=899300ps TO=899600ps
.MEASURE TRAN P_static_692 AVG POWER FROM=900600ps TO=900900ps
.MEASURE TRAN P_static_693 AVG POWER FROM=901900ps TO=902200ps
.MEASURE TRAN P_static_694 AVG POWER FROM=903200ps TO=903500ps
.MEASURE TRAN P_static_695 AVG POWER FROM=904500ps TO=904800ps
.MEASURE TRAN P_static_696 AVG POWER FROM=905800ps TO=906100ps
.MEASURE TRAN P_static_697 AVG POWER FROM=907100ps TO=907400ps
.MEASURE TRAN P_static_698 AVG POWER FROM=908400ps TO=908700ps
.MEASURE TRAN P_static_699 AVG POWER FROM=909700ps TO=910000ps
.MEASURE TRAN P_static_700 AVG POWER FROM=911000ps TO=911300ps
.MEASURE TRAN P_static_701 AVG POWER FROM=912300ps TO=912600ps
.MEASURE TRAN P_static_702 AVG POWER FROM=913600ps TO=913900ps
.MEASURE TRAN P_static_703 AVG POWER FROM=914900ps TO=915200ps
.MEASURE TRAN P_static_704 AVG POWER FROM=916200ps TO=916500ps
.MEASURE TRAN P_static_705 AVG POWER FROM=917500ps TO=917800ps
.MEASURE TRAN P_static_706 AVG POWER FROM=918800ps TO=919100ps
.MEASURE TRAN P_static_707 AVG POWER FROM=920100ps TO=920400ps
.MEASURE TRAN P_static_708 AVG POWER FROM=921400ps TO=921700ps
.MEASURE TRAN P_static_709 AVG POWER FROM=922700ps TO=923000ps
.MEASURE TRAN P_static_710 AVG POWER FROM=924000ps TO=924300ps
.MEASURE TRAN P_static_711 AVG POWER FROM=925300ps TO=925600ps
.MEASURE TRAN P_static_712 AVG POWER FROM=926600ps TO=926900ps
.MEASURE TRAN P_static_713 AVG POWER FROM=927900ps TO=928200ps
.MEASURE TRAN P_static_714 AVG POWER FROM=929200ps TO=929500ps
.MEASURE TRAN P_static_715 AVG POWER FROM=930500ps TO=930800ps
.MEASURE TRAN P_static_716 AVG POWER FROM=931800ps TO=932100ps
.MEASURE TRAN P_static_717 AVG POWER FROM=933100ps TO=933400ps
.MEASURE TRAN P_static_718 AVG POWER FROM=934400ps TO=934700ps
.MEASURE TRAN P_static_719 AVG POWER FROM=935700ps TO=936000ps
.MEASURE TRAN P_static_720 AVG POWER FROM=937000ps TO=937300ps
.MEASURE TRAN P_static_721 AVG POWER FROM=938300ps TO=938600ps
.MEASURE TRAN P_static_722 AVG POWER FROM=939600ps TO=939900ps
.MEASURE TRAN P_static_723 AVG POWER FROM=940900ps TO=941200ps
.MEASURE TRAN P_static_724 AVG POWER FROM=942200ps TO=942500ps
.MEASURE TRAN P_static_725 AVG POWER FROM=943500ps TO=943800ps
.MEASURE TRAN P_static_726 AVG POWER FROM=944800ps TO=945100ps
.MEASURE TRAN P_static_727 AVG POWER FROM=946100ps TO=946400ps
.MEASURE TRAN P_static_728 AVG POWER FROM=947400ps TO=947700ps
.MEASURE TRAN P_static_729 AVG POWER FROM=948700ps TO=949000ps
.MEASURE TRAN P_static_730 AVG POWER FROM=950000ps TO=950300ps
.MEASURE TRAN P_static_731 AVG POWER FROM=951300ps TO=951600ps
.MEASURE TRAN P_static_732 AVG POWER FROM=952600ps TO=952900ps
.MEASURE TRAN P_static_733 AVG POWER FROM=953900ps TO=954200ps
.MEASURE TRAN P_static_734 AVG POWER FROM=955200ps TO=955500ps
.MEASURE TRAN P_static_735 AVG POWER FROM=956500ps TO=956800ps
.MEASURE TRAN P_static_736 AVG POWER FROM=957800ps TO=958100ps
.MEASURE TRAN P_static_737 AVG POWER FROM=959100ps TO=959400ps
.MEASURE TRAN P_static_738 AVG POWER FROM=960400ps TO=960700ps
.MEASURE TRAN P_static_739 AVG POWER FROM=961700ps TO=962000ps
.MEASURE TRAN P_static_740 AVG POWER FROM=963000ps TO=963300ps
.MEASURE TRAN P_static_741 AVG POWER FROM=964300ps TO=964600ps
.MEASURE TRAN P_static_742 AVG POWER FROM=965600ps TO=965900ps
.MEASURE TRAN P_static_743 AVG POWER FROM=966900ps TO=967200ps
.MEASURE TRAN P_static_744 AVG POWER FROM=968200ps TO=968500ps
.MEASURE TRAN P_static_745 AVG POWER FROM=969500ps TO=969800ps
.MEASURE TRAN P_static_746 AVG POWER FROM=970800ps TO=971100ps
.MEASURE TRAN P_static_747 AVG POWER FROM=972100ps TO=972400ps
.MEASURE TRAN P_static_748 AVG POWER FROM=973400ps TO=973700ps
.MEASURE TRAN P_static_749 AVG POWER FROM=974700ps TO=975000ps
.MEASURE TRAN P_static_750 AVG POWER FROM=976000ps TO=976300ps
.MEASURE TRAN P_static_751 AVG POWER FROM=977300ps TO=977600ps
.MEASURE TRAN P_static_752 AVG POWER FROM=978600ps TO=978900ps
.MEASURE TRAN P_static_753 AVG POWER FROM=979900ps TO=980200ps
.MEASURE TRAN P_static_754 AVG POWER FROM=981200ps TO=981500ps
.MEASURE TRAN P_static_755 AVG POWER FROM=982500ps TO=982800ps
.MEASURE TRAN P_static_756 AVG POWER FROM=983800ps TO=984100ps
.MEASURE TRAN P_static_757 AVG POWER FROM=985100ps TO=985400ps
.MEASURE TRAN P_static_758 AVG POWER FROM=986400ps TO=986700ps
.MEASURE TRAN P_static_759 AVG POWER FROM=987700ps TO=988000ps
.MEASURE TRAN P_static_760 AVG POWER FROM=989000ps TO=989300ps
.MEASURE TRAN P_static_761 AVG POWER FROM=990300ps TO=990600ps
.MEASURE TRAN P_static_762 AVG POWER FROM=991600ps TO=991900ps
.MEASURE TRAN P_static_763 AVG POWER FROM=992900ps TO=993200ps
.MEASURE TRAN P_static_764 AVG POWER FROM=994200ps TO=994500ps
.MEASURE TRAN P_static_765 AVG POWER FROM=995500ps TO=995800ps
.MEASURE TRAN P_static_766 AVG POWER FROM=996800ps TO=997100ps
.MEASURE TRAN P_static_767 AVG POWER FROM=998100ps TO=998400ps
.MEASURE TRAN P_static_768 AVG POWER FROM=999400ps TO=999700ps
.MEASURE TRAN P_static_769 AVG POWER FROM=1000700ps TO=1001000ps
.MEASURE TRAN P_static_770 AVG POWER FROM=1002000ps TO=1002300ps
.MEASURE TRAN P_static_771 AVG POWER FROM=1003300ps TO=1003600ps
.MEASURE TRAN P_static_772 AVG POWER FROM=1004600ps TO=1004900ps
.MEASURE TRAN P_static_773 AVG POWER FROM=1005900ps TO=1006200ps
.MEASURE TRAN P_static_774 AVG POWER FROM=1007200ps TO=1007500ps
.MEASURE TRAN P_static_775 AVG POWER FROM=1008500ps TO=1008800ps
.MEASURE TRAN P_static_776 AVG POWER FROM=1009800ps TO=1010100ps
.MEASURE TRAN P_static_777 AVG POWER FROM=1011100ps TO=1011400ps
.MEASURE TRAN P_static_778 AVG POWER FROM=1012400ps TO=1012700ps
.MEASURE TRAN P_static_779 AVG POWER FROM=1013700ps TO=1014000ps
.MEASURE TRAN P_static_780 AVG POWER FROM=1015000ps TO=1015300ps
.MEASURE TRAN P_static_781 AVG POWER FROM=1016300ps TO=1016600ps
.MEASURE TRAN P_static_782 AVG POWER FROM=1017600ps TO=1017900ps
.MEASURE TRAN P_static_783 AVG POWER FROM=1018900ps TO=1019200ps
.MEASURE TRAN P_static_784 AVG POWER FROM=1020200ps TO=1020500ps
.MEASURE TRAN P_static_785 AVG POWER FROM=1021500ps TO=1021800ps
.MEASURE TRAN P_static_786 AVG POWER FROM=1022800ps TO=1023100ps
.MEASURE TRAN P_static_787 AVG POWER FROM=1024100ps TO=1024400ps
.MEASURE TRAN P_static_788 AVG POWER FROM=1025400ps TO=1025700ps
.MEASURE TRAN P_static_789 AVG POWER FROM=1026700ps TO=1027000ps
.MEASURE TRAN P_static_790 AVG POWER FROM=1028000ps TO=1028300ps
.MEASURE TRAN P_static_791 AVG POWER FROM=1029300ps TO=1029600ps
.MEASURE TRAN P_static_792 AVG POWER FROM=1030600ps TO=1030900ps
.MEASURE TRAN P_static_793 AVG POWER FROM=1031900ps TO=1032200ps
.MEASURE TRAN P_static_794 AVG POWER FROM=1033200ps TO=1033500ps
.MEASURE TRAN P_static_795 AVG POWER FROM=1034500ps TO=1034800ps
.MEASURE TRAN P_static_796 AVG POWER FROM=1035800ps TO=1036100ps
.MEASURE TRAN P_static_797 AVG POWER FROM=1037100ps TO=1037400ps
.MEASURE TRAN P_static_798 AVG POWER FROM=1038400ps TO=1038700ps
.MEASURE TRAN P_static_799 AVG POWER FROM=1039700ps TO=1040000ps
.MEASURE TRAN P_static_800 AVG POWER FROM=1041000ps TO=1041300ps
.MEASURE TRAN P_static_801 AVG POWER FROM=1042300ps TO=1042600ps
.MEASURE TRAN P_static_802 AVG POWER FROM=1043600ps TO=1043900ps
.MEASURE TRAN P_static_803 AVG POWER FROM=1044900ps TO=1045200ps
.MEASURE TRAN P_static_804 AVG POWER FROM=1046200ps TO=1046500ps
.MEASURE TRAN P_static_805 AVG POWER FROM=1047500ps TO=1047800ps
.MEASURE TRAN P_static_806 AVG POWER FROM=1048800ps TO=1049100ps
.MEASURE TRAN P_static_807 AVG POWER FROM=1050100ps TO=1050400ps
.MEASURE TRAN P_static_808 AVG POWER FROM=1051400ps TO=1051700ps
.MEASURE TRAN P_static_809 AVG POWER FROM=1052700ps TO=1053000ps
.MEASURE TRAN P_static_810 AVG POWER FROM=1054000ps TO=1054300ps
.MEASURE TRAN P_static_811 AVG POWER FROM=1055300ps TO=1055600ps
.MEASURE TRAN P_static_812 AVG POWER FROM=1056600ps TO=1056900ps
.MEASURE TRAN P_static_813 AVG POWER FROM=1057900ps TO=1058200ps
.MEASURE TRAN P_static_814 AVG POWER FROM=1059200ps TO=1059500ps
.MEASURE TRAN P_static_815 AVG POWER FROM=1060500ps TO=1060800ps
.MEASURE TRAN P_static_816 AVG POWER FROM=1061800ps TO=1062100ps
.MEASURE TRAN P_static_817 AVG POWER FROM=1063100ps TO=1063400ps
.MEASURE TRAN P_static_818 AVG POWER FROM=1064400ps TO=1064700ps
.MEASURE TRAN P_static_819 AVG POWER FROM=1065700ps TO=1066000ps
.MEASURE TRAN P_static_820 AVG POWER FROM=1067000ps TO=1067300ps
.MEASURE TRAN P_static_821 AVG POWER FROM=1068300ps TO=1068600ps
.MEASURE TRAN P_static_822 AVG POWER FROM=1069600ps TO=1069900ps
.MEASURE TRAN P_static_823 AVG POWER FROM=1070900ps TO=1071200ps
.MEASURE TRAN P_static_824 AVG POWER FROM=1072200ps TO=1072500ps
.MEASURE TRAN P_static_825 AVG POWER FROM=1073500ps TO=1073800ps
.MEASURE TRAN P_static_826 AVG POWER FROM=1074800ps TO=1075100ps
.MEASURE TRAN P_static_827 AVG POWER FROM=1076100ps TO=1076400ps
.MEASURE TRAN P_static_828 AVG POWER FROM=1077400ps TO=1077700ps
.MEASURE TRAN P_static_829 AVG POWER FROM=1078700ps TO=1079000ps
.MEASURE TRAN P_static_830 AVG POWER FROM=1080000ps TO=1080300ps
.MEASURE TRAN P_static_831 AVG POWER FROM=1081300ps TO=1081600ps
.MEASURE TRAN P_static_832 AVG POWER FROM=1082600ps TO=1082900ps
.MEASURE TRAN P_static_833 AVG POWER FROM=1083900ps TO=1084200ps
.MEASURE TRAN P_static_834 AVG POWER FROM=1085200ps TO=1085500ps
.MEASURE TRAN P_static_835 AVG POWER FROM=1086500ps TO=1086800ps
.MEASURE TRAN P_static_836 AVG POWER FROM=1087800ps TO=1088100ps
.MEASURE TRAN P_static_837 AVG POWER FROM=1089100ps TO=1089400ps
.MEASURE TRAN P_static_838 AVG POWER FROM=1090400ps TO=1090700ps
.MEASURE TRAN P_static_839 AVG POWER FROM=1091700ps TO=1092000ps
.MEASURE TRAN P_static_840 AVG POWER FROM=1093000ps TO=1093300ps
.MEASURE TRAN P_static_841 AVG POWER FROM=1094300ps TO=1094600ps
.MEASURE TRAN P_static_842 AVG POWER FROM=1095600ps TO=1095900ps
.MEASURE TRAN P_static_843 AVG POWER FROM=1096900ps TO=1097200ps
.MEASURE TRAN P_static_844 AVG POWER FROM=1098200ps TO=1098500ps
.MEASURE TRAN P_static_845 AVG POWER FROM=1099500ps TO=1099800ps
.MEASURE TRAN P_static_846 AVG POWER FROM=1100800ps TO=1101100ps
.MEASURE TRAN P_static_847 AVG POWER FROM=1102100ps TO=1102400ps
.MEASURE TRAN P_static_848 AVG POWER FROM=1103400ps TO=1103700ps
.MEASURE TRAN P_static_849 AVG POWER FROM=1104700ps TO=1105000ps
.MEASURE TRAN P_static_850 AVG POWER FROM=1106000ps TO=1106300ps
.MEASURE TRAN P_static_851 AVG POWER FROM=1107300ps TO=1107600ps
.MEASURE TRAN P_static_852 AVG POWER FROM=1108600ps TO=1108900ps
.MEASURE TRAN P_static_853 AVG POWER FROM=1109900ps TO=1110200ps
.MEASURE TRAN P_static_854 AVG POWER FROM=1111200ps TO=1111500ps
.MEASURE TRAN P_static_855 AVG POWER FROM=1112500ps TO=1112800ps
.MEASURE TRAN P_static_856 AVG POWER FROM=1113800ps TO=1114100ps
.MEASURE TRAN P_static_857 AVG POWER FROM=1115100ps TO=1115400ps
.MEASURE TRAN P_static_858 AVG POWER FROM=1116400ps TO=1116700ps
.MEASURE TRAN P_static_859 AVG POWER FROM=1117700ps TO=1118000ps
.MEASURE TRAN P_static_860 AVG POWER FROM=1119000ps TO=1119300ps
.MEASURE TRAN P_static_861 AVG POWER FROM=1120300ps TO=1120600ps
.MEASURE TRAN P_static_862 AVG POWER FROM=1121600ps TO=1121900ps
.MEASURE TRAN P_static_863 AVG POWER FROM=1122900ps TO=1123200ps
.MEASURE TRAN P_static_864 AVG POWER FROM=1124200ps TO=1124500ps
.MEASURE TRAN P_static_865 AVG POWER FROM=1125500ps TO=1125800ps
.MEASURE TRAN P_static_866 AVG POWER FROM=1126800ps TO=1127100ps
.MEASURE TRAN P_static_867 AVG POWER FROM=1128100ps TO=1128400ps
.MEASURE TRAN P_static_868 AVG POWER FROM=1129400ps TO=1129700ps
.MEASURE TRAN P_static_869 AVG POWER FROM=1130700ps TO=1131000ps
.MEASURE TRAN P_static_870 AVG POWER FROM=1132000ps TO=1132300ps
.MEASURE TRAN P_static_871 AVG POWER FROM=1133300ps TO=1133600ps
.MEASURE TRAN P_static_872 AVG POWER FROM=1134600ps TO=1134900ps
.MEASURE TRAN P_static_873 AVG POWER FROM=1135900ps TO=1136200ps
.MEASURE TRAN P_static_874 AVG POWER FROM=1137200ps TO=1137500ps
.MEASURE TRAN P_static_875 AVG POWER FROM=1138500ps TO=1138800ps
.MEASURE TRAN P_static_876 AVG POWER FROM=1139800ps TO=1140100ps
.MEASURE TRAN P_static_877 AVG POWER FROM=1141100ps TO=1141400ps
.MEASURE TRAN P_static_878 AVG POWER FROM=1142400ps TO=1142700ps
.MEASURE TRAN P_static_879 AVG POWER FROM=1143700ps TO=1144000ps
.MEASURE TRAN P_static_880 AVG POWER FROM=1145000ps TO=1145300ps
.MEASURE TRAN P_static_881 AVG POWER FROM=1146300ps TO=1146600ps
.MEASURE TRAN P_static_882 AVG POWER FROM=1147600ps TO=1147900ps
.MEASURE TRAN P_static_883 AVG POWER FROM=1148900ps TO=1149200ps
.MEASURE TRAN P_static_884 AVG POWER FROM=1150200ps TO=1150500ps
.MEASURE TRAN P_static_885 AVG POWER FROM=1151500ps TO=1151800ps
.MEASURE TRAN P_static_886 AVG POWER FROM=1152800ps TO=1153100ps
.MEASURE TRAN P_static_887 AVG POWER FROM=1154100ps TO=1154400ps
.MEASURE TRAN P_static_888 AVG POWER FROM=1155400ps TO=1155700ps
.MEASURE TRAN P_static_889 AVG POWER FROM=1156700ps TO=1157000ps
.MEASURE TRAN P_static_890 AVG POWER FROM=1158000ps TO=1158300ps
.MEASURE TRAN P_static_891 AVG POWER FROM=1159300ps TO=1159600ps
.MEASURE TRAN P_static_892 AVG POWER FROM=1160600ps TO=1160900ps
.MEASURE TRAN P_static_893 AVG POWER FROM=1161900ps TO=1162200ps
.MEASURE TRAN P_static_894 AVG POWER FROM=1163200ps TO=1163500ps
.MEASURE TRAN P_static_895 AVG POWER FROM=1164500ps TO=1164800ps
.MEASURE TRAN P_static_896 AVG POWER FROM=1165800ps TO=1166100ps
.MEASURE TRAN P_static_897 AVG POWER FROM=1167100ps TO=1167400ps
.MEASURE TRAN P_static_898 AVG POWER FROM=1168400ps TO=1168700ps
.MEASURE TRAN P_static_899 AVG POWER FROM=1169700ps TO=1170000ps
.MEASURE TRAN P_static_900 AVG POWER FROM=1171000ps TO=1171300ps
.MEASURE TRAN P_static_901 AVG POWER FROM=1172300ps TO=1172600ps
.MEASURE TRAN P_static_902 AVG POWER FROM=1173600ps TO=1173900ps
.MEASURE TRAN P_static_903 AVG POWER FROM=1174900ps TO=1175200ps
.MEASURE TRAN P_static_904 AVG POWER FROM=1176200ps TO=1176500ps
.MEASURE TRAN P_static_905 AVG POWER FROM=1177500ps TO=1177800ps
.MEASURE TRAN P_static_906 AVG POWER FROM=1178800ps TO=1179100ps
.MEASURE TRAN P_static_907 AVG POWER FROM=1180100ps TO=1180400ps
.MEASURE TRAN P_static_908 AVG POWER FROM=1181400ps TO=1181700ps
.MEASURE TRAN P_static_909 AVG POWER FROM=1182700ps TO=1183000ps
.MEASURE TRAN P_static_910 AVG POWER FROM=1184000ps TO=1184300ps
.MEASURE TRAN P_static_911 AVG POWER FROM=1185300ps TO=1185600ps
.MEASURE TRAN P_static_912 AVG POWER FROM=1186600ps TO=1186900ps
.MEASURE TRAN P_static_913 AVG POWER FROM=1187900ps TO=1188200ps
.MEASURE TRAN P_static_914 AVG POWER FROM=1189200ps TO=1189500ps
.MEASURE TRAN P_static_915 AVG POWER FROM=1190500ps TO=1190800ps
.MEASURE TRAN P_static_916 AVG POWER FROM=1191800ps TO=1192100ps
.MEASURE TRAN P_static_917 AVG POWER FROM=1193100ps TO=1193400ps
.MEASURE TRAN P_static_918 AVG POWER FROM=1194400ps TO=1194700ps
.MEASURE TRAN P_static_919 AVG POWER FROM=1195700ps TO=1196000ps
.MEASURE TRAN P_static_920 AVG POWER FROM=1197000ps TO=1197300ps
.MEASURE TRAN P_static_921 AVG POWER FROM=1198300ps TO=1198600ps
.MEASURE TRAN P_static_922 AVG POWER FROM=1199600ps TO=1199900ps
.MEASURE TRAN P_static_923 AVG POWER FROM=1200900ps TO=1201200ps
.MEASURE TRAN P_static_924 AVG POWER FROM=1202200ps TO=1202500ps
.MEASURE TRAN P_static_925 AVG POWER FROM=1203500ps TO=1203800ps
.MEASURE TRAN P_static_926 AVG POWER FROM=1204800ps TO=1205100ps
.MEASURE TRAN P_static_927 AVG POWER FROM=1206100ps TO=1206400ps
.MEASURE TRAN P_static_928 AVG POWER FROM=1207400ps TO=1207700ps
.MEASURE TRAN P_static_929 AVG POWER FROM=1208700ps TO=1209000ps
.MEASURE TRAN P_static_930 AVG POWER FROM=1210000ps TO=1210300ps
.MEASURE TRAN P_static_931 AVG POWER FROM=1211300ps TO=1211600ps
.MEASURE TRAN P_static_932 AVG POWER FROM=1212600ps TO=1212900ps
.MEASURE TRAN P_static_933 AVG POWER FROM=1213900ps TO=1214200ps
.MEASURE TRAN P_static_934 AVG POWER FROM=1215200ps TO=1215500ps
.MEASURE TRAN P_static_935 AVG POWER FROM=1216500ps TO=1216800ps
.MEASURE TRAN P_static_936 AVG POWER FROM=1217800ps TO=1218100ps
.MEASURE TRAN P_static_937 AVG POWER FROM=1219100ps TO=1219400ps
.MEASURE TRAN P_static_938 AVG POWER FROM=1220400ps TO=1220700ps
.MEASURE TRAN P_static_939 AVG POWER FROM=1221700ps TO=1222000ps
.MEASURE TRAN P_static_940 AVG POWER FROM=1223000ps TO=1223300ps
.MEASURE TRAN P_static_941 AVG POWER FROM=1224300ps TO=1224600ps
.MEASURE TRAN P_static_942 AVG POWER FROM=1225600ps TO=1225900ps
.MEASURE TRAN P_static_943 AVG POWER FROM=1226900ps TO=1227200ps
.MEASURE TRAN P_static_944 AVG POWER FROM=1228200ps TO=1228500ps
.MEASURE TRAN P_static_945 AVG POWER FROM=1229500ps TO=1229800ps
.MEASURE TRAN P_static_946 AVG POWER FROM=1230800ps TO=1231100ps
.MEASURE TRAN P_static_947 AVG POWER FROM=1232100ps TO=1232400ps
.MEASURE TRAN P_static_948 AVG POWER FROM=1233400ps TO=1233700ps
.MEASURE TRAN P_static_949 AVG POWER FROM=1234700ps TO=1235000ps
.MEASURE TRAN P_static_950 AVG POWER FROM=1236000ps TO=1236300ps
.MEASURE TRAN P_static_951 AVG POWER FROM=1237300ps TO=1237600ps
.MEASURE TRAN P_static_952 AVG POWER FROM=1238600ps TO=1238900ps
.MEASURE TRAN P_static_953 AVG POWER FROM=1239900ps TO=1240200ps
.MEASURE TRAN P_static_954 AVG POWER FROM=1241200ps TO=1241500ps
.MEASURE TRAN P_static_955 AVG POWER FROM=1242500ps TO=1242800ps
.MEASURE TRAN P_static_956 AVG POWER FROM=1243800ps TO=1244100ps
.MEASURE TRAN P_static_957 AVG POWER FROM=1245100ps TO=1245400ps
.MEASURE TRAN P_static_958 AVG POWER FROM=1246400ps TO=1246700ps
.MEASURE TRAN P_static_959 AVG POWER FROM=1247700ps TO=1248000ps
.MEASURE TRAN P_static_960 AVG POWER FROM=1249000ps TO=1249300ps
.MEASURE TRAN P_static_961 AVG POWER FROM=1250300ps TO=1250600ps
.MEASURE TRAN P_static_962 AVG POWER FROM=1251600ps TO=1251900ps
.MEASURE TRAN P_static_963 AVG POWER FROM=1252900ps TO=1253200ps
.MEASURE TRAN P_static_964 AVG POWER FROM=1254200ps TO=1254500ps
.MEASURE TRAN P_static_965 AVG POWER FROM=1255500ps TO=1255800ps
.MEASURE TRAN P_static_966 AVG POWER FROM=1256800ps TO=1257100ps
.MEASURE TRAN P_static_967 AVG POWER FROM=1258100ps TO=1258400ps
.MEASURE TRAN P_static_968 AVG POWER FROM=1259400ps TO=1259700ps
.MEASURE TRAN P_static_969 AVG POWER FROM=1260700ps TO=1261000ps
.MEASURE TRAN P_static_970 AVG POWER FROM=1262000ps TO=1262300ps
.MEASURE TRAN P_static_971 AVG POWER FROM=1263300ps TO=1263600ps
.MEASURE TRAN P_static_972 AVG POWER FROM=1264600ps TO=1264900ps
.MEASURE TRAN P_static_973 AVG POWER FROM=1265900ps TO=1266200ps
.MEASURE TRAN P_static_974 AVG POWER FROM=1267200ps TO=1267500ps
.MEASURE TRAN P_static_975 AVG POWER FROM=1268500ps TO=1268800ps
.MEASURE TRAN P_static_976 AVG POWER FROM=1269800ps TO=1270100ps
.MEASURE TRAN P_static_977 AVG POWER FROM=1271100ps TO=1271400ps
.MEASURE TRAN P_static_978 AVG POWER FROM=1272400ps TO=1272700ps
.MEASURE TRAN P_static_979 AVG POWER FROM=1273700ps TO=1274000ps
.MEASURE TRAN P_static_980 AVG POWER FROM=1275000ps TO=1275300ps
.MEASURE TRAN P_static_981 AVG POWER FROM=1276300ps TO=1276600ps
.MEASURE TRAN P_static_982 AVG POWER FROM=1277600ps TO=1277900ps
.MEASURE TRAN P_static_983 AVG POWER FROM=1278900ps TO=1279200ps
.MEASURE TRAN P_static_984 AVG POWER FROM=1280200ps TO=1280500ps
.MEASURE TRAN P_static_985 AVG POWER FROM=1281500ps TO=1281800ps
.MEASURE TRAN P_static_986 AVG POWER FROM=1282800ps TO=1283100ps
.MEASURE TRAN P_static_987 AVG POWER FROM=1284100ps TO=1284400ps
.MEASURE TRAN P_static_988 AVG POWER FROM=1285400ps TO=1285700ps
.MEASURE TRAN P_static_989 AVG POWER FROM=1286700ps TO=1287000ps
.MEASURE TRAN P_static_990 AVG POWER FROM=1288000ps TO=1288300ps
.MEASURE TRAN P_static_991 AVG POWER FROM=1289300ps TO=1289600ps
.MEASURE TRAN P_static_992 AVG POWER FROM=1290600ps TO=1290900ps
.MEASURE TRAN P_static_993 AVG POWER FROM=1291900ps TO=1292200ps
.MEASURE TRAN P_static_994 AVG POWER FROM=1293200ps TO=1293500ps
.MEASURE TRAN P_static_995 AVG POWER FROM=1294500ps TO=1294800ps
.MEASURE TRAN P_static_996 AVG POWER FROM=1295800ps TO=1296100ps
.MEASURE TRAN P_static_997 AVG POWER FROM=1297100ps TO=1297400ps
.MEASURE TRAN P_static_998 AVG POWER FROM=1298400ps TO=1298700ps
.MEASURE TRAN P_static_999 AVG POWER FROM=1299700ps TO=1300000ps

* --------------------------------------------------------
